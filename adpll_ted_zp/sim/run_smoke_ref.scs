// pll_step2_main.scs — generated paper-reproduction top-level
// fref=100M XO, fvco=8G, Nint2=80, frac2=0.0, dual_core=True
simulator lang=spectre

include "/home/lib/tsmc_12nm_installed/pdk/models/toplevel.scs" section=top_tt
include "dtc_10b.scs"
include "vco_dual_8g.scs"
include "spd_cmp_gm.scs"
ahdl_include "pll_mmd_edge.va"
ahdl_include "pll_lms.va"
ahdl_include "pll_dtc_decoder_10b.va"
ahdl_include "pll_hybrid_aux.va"

Vvdd (VDD 0) vsource dc=0.8
Vvss (VSS 0) vsource dc=0
Vref (REF 0) vsource type=pulse val0=0 val1=0.8 period=1.000000e-08 width=5.000000e-09 rise=10p fall=10p
Vbspd (VBSPD 0) vsource dc=0.52
Vbcmp (VBCMP 0) vsource dc=0.8
Vbgm  (VBGM 0) vsource dc=0.8

Venv2 (EN2 0) vsource dc=0.8
Xvco (VDD VSS VCTRL OUTP OUTN EN2) vco_dual_8g
// plan A': decoder moved INSIDE dtc_10b (paper architecture); only 11 external ports
Xdtc (CK2X CKDTCD VDD VSS CKFB KDTC EPSC SEL ALT VDCC RDCC) dtc_10b
Xspd (VBSPD CKRST CKFB VHOLD VRAMP VDD VSS) spd_x
Xcmp (VHOLD VREF VBCMP EBIT VDD VSS) cmp_x
Xgm  (VHOLD VREF VBGM VI VDD VSS) gm_x

Edbl (CK2X 0 REF 0) vcvs gain=1.0  // step2: 100M 参考不经倍频
Einv (CKRSTI 0 CKDTCD 0) vcvs gain=-1.0
Vrstofs (VDC08 0) vsource dc=0.8
Esumrst (CKRST VDC08 CKRSTI 0) vcvs gain=1.0

Minvbuf_n (NBUF1 BUFFIN VSS VSS) nch_svt_mac l=16n nfin=2 w=58n multi=1 nf=4 sd=74n sa=90n sb=90n ploda1=16n ploda2=0 ploda3=0 plodb1=16n plodb2=0 plodb3=0 nf_flag=1 smbt=1M smbb=1M dinsaflag=0 ppitch=0 spot=103n spob=103n spotl1=103n spobl1=103n spotl2=103n spobl2=103n spotr1=103n spobr1=103n spotr2=103n spobr2=103n
Minvbuf_p (NBUF1 BUFFIN VDD VDD) pch_svt_mac l=16n nfin=2 w=58n multi=1 nf=4 sd=74n sa=90n sb=90n ploda1=16n ploda2=0 ploda3=0 plodb1=16n plodb2=0 plodb3=0 nf_flag=1 smbt=1M smbb=1M dinsaflag=0 ppitch=0 spot=103n spob=103n spotl1=103n spobl1=103n spotl2=103n spobl2=103n spotr1=103n spobr1=103n spotr2=103n spobr2=103n
Minvbuf2_n (MMDIN NBUF1 VSS VSS) nch_svt_mac l=16n nfin=2 w=58n multi=1 nf=4 sd=74n sa=90n sb=90n ploda1=16n ploda2=0 ploda3=0 plodb1=16n plodb2=0 plodb3=0 nf_flag=1 smbt=1M smbb=1M dinsaflag=0 ppitch=0 spot=103n spob=103n spotl1=103n spobl1=103n spotl2=103n spobl2=103n spotr1=103n spobr1=103n spotr2=103n spobr2=103n
Minvbuf2_p (MMDIN NBUF1 VDD VDD) pch_svt_mac l=16n nfin=2 w=58n multi=1 nf=4 sd=74n sa=90n sb=90n ploda1=16n ploda2=0 ploda3=0 plodb1=16n plodb2=0 plodb3=0 nf_flag=1 smbt=1M smbb=1M dinsaflag=0 ppitch=0 spot=103n spob=103n spotl1=103n spobl1=103n spotl2=103n spobl2=103n spotr1=103n spobr1=103n spotr2=103n spobr2=103n
Rbuf (OUTP BUFFIN) resistor r=1k

Xmmd (MMDIN CKFB SEL ALT EPSC ERR) pll_mmd_edge Nint2=80.0 frac2=0.0 vth=0.7
Xclkl (CKFB CLKLMS) pll_clk_lms
Xlms (CLKLMS EBIT SEL ALT EPSC KDTC VDCC RDCC VREF) pll_lms \
    mu_k=0.0 mu_v=0.0 mu_r=1e-13 mu_off=4.2e-13 K0=1.0 vdcc0=12e-12 rdcc0=-12e-12 ohat0=32e-12 \
    offset_s=32e-12 vref0=0.15 fref=1.000000e+08 m_slope=1e9 mode=1 tscale=1e-6 seed=121

Xci (VI 0) capacitor c=2p ic=0.55
// 预充电: 0-2ns 注入 550uA -> VI≈0.55V, 环路从近锁定状态启动
// (VCTRL=0 时 VCO f_min≈3.08G -> CKFB≈76M 与 2×fref 斜坡栅格近同步,
//  采样相位冻结在复位区 -> 谐波锁死, 无外力无法捕获)
Iinj (VI 0) isource type=pulse val0=0 val1=-550u delay=0 width=2n period=1m rise=10p fall=10p
Rf (VHOLD VHF) resistor r=5k
Cf (VHF 0) capacitor c=5p
Ep (VN1 0 VHF 0) vcvs gain=0.06
Esum (VCTRL VN1 VI 0) vcvs gain=1.0

plltran tran stop=300n maxstep=2p errpreset=liberal method=gear2only skipdc=yes ic="OUTP=0.6"
save OUTP CKFB VCTRL VI VHOLD EBIT MMDIN NBUF1 VREF VDCC RDCC KDTC VRAMP SEL EPSC CK2X CKDTCD CKRST
saveOptions options save=selected
