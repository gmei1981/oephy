// dtc_code448.scs — DTC delay vs code (thermometer pattern of first 448 gates on)
simulator lang=spectre
include "/home/lib/tsmc_12nm_installed/pdk/models/toplevel.scs" section=top_tt
include "dtc_10b.scs"

Vvdd (VDD 0) vsource dc=0.8
Vvss (VSS 0) vsource dc=0
Vin (CKIN 0) vsource type=pulse val0=0 val1=0.8 period=6.510417n width=3.25n rise=10p fall=10p
Vg0 (c0 0) vsource dc=0.8
Vg1 (c1 0) vsource dc=0.8
Vg2 (c2 0) vsource dc=0.8
Vg3 (c3 0) vsource dc=0.8
Vg4 (c4 0) vsource dc=0.8
Vg5 (c5 0) vsource dc=0.8
Vg6 (c6 0) vsource dc=0.8
Vg7 (c7 0) vsource dc=0.8
Vg8 (c8 0) vsource dc=0.8
Vg9 (c9 0) vsource dc=0.8
Vg10 (c10 0) vsource dc=0.8
Vg11 (c11 0) vsource dc=0.8
Vg12 (c12 0) vsource dc=0.8
Vg13 (c13 0) vsource dc=0.8
Vg14 (c14 0) vsource dc=0.8
Vg15 (c15 0) vsource dc=0.8
Vg16 (c16 0) vsource dc=0.8
Vg17 (c17 0) vsource dc=0.8
Vg18 (c18 0) vsource dc=0.8
Vg19 (c19 0) vsource dc=0.8
Vg20 (c20 0) vsource dc=0.8
Vg21 (c21 0) vsource dc=0.8
Vg22 (c22 0) vsource dc=0.8
Vg23 (c23 0) vsource dc=0.8
Vg24 (c24 0) vsource dc=0.8
Vg25 (c25 0) vsource dc=0.8
Vg26 (c26 0) vsource dc=0.8
Vg27 (c27 0) vsource dc=0.8
Vg28 (c28 0) vsource dc=0.8
Vg29 (c29 0) vsource dc=0.8
Vg30 (c30 0) vsource dc=0.8
Vg31 (c31 0) vsource dc=0.8
Vg32 (c32 0) vsource dc=0.8
Vg33 (c33 0) vsource dc=0.8
Vg34 (c34 0) vsource dc=0.8
Vg35 (c35 0) vsource dc=0.8
Vg36 (c36 0) vsource dc=0.8
Vg37 (c37 0) vsource dc=0.8
Vg38 (c38 0) vsource dc=0.8
Vg39 (c39 0) vsource dc=0.8
Vg40 (c40 0) vsource dc=0.8
Vg41 (c41 0) vsource dc=0.8
Vg42 (c42 0) vsource dc=0.8
Vg43 (c43 0) vsource dc=0.8
Vg44 (c44 0) vsource dc=0.8
Vg45 (c45 0) vsource dc=0.8
Vg46 (c46 0) vsource dc=0.8
Vg47 (c47 0) vsource dc=0.8
Vg48 (c48 0) vsource dc=0.8
Vg49 (c49 0) vsource dc=0.8
Vg50 (c50 0) vsource dc=0.8
Vg51 (c51 0) vsource dc=0.8
Vg52 (c52 0) vsource dc=0.8
Vg53 (c53 0) vsource dc=0.8
Vg54 (c54 0) vsource dc=0.8
Vg55 (c55 0) vsource dc=0.8
Vg56 (c56 0) vsource dc=0.8
Vg57 (c57 0) vsource dc=0.8
Vg58 (c58 0) vsource dc=0.8
Vg59 (c59 0) vsource dc=0.8
Vg60 (c60 0) vsource dc=0.8
Vg61 (c61 0) vsource dc=0.8
Vg62 (c62 0) vsource dc=0.8
Vg63 (c63 0) vsource dc=0.8
Vg64 (c64 0) vsource dc=0.8
Vg65 (c65 0) vsource dc=0.8
Vg66 (c66 0) vsource dc=0.8
Vg67 (c67 0) vsource dc=0.8
Vg68 (c68 0) vsource dc=0.8
Vg69 (c69 0) vsource dc=0.8
Vg70 (c70 0) vsource dc=0.8
Vg71 (c71 0) vsource dc=0.8
Vg72 (c72 0) vsource dc=0.8
Vg73 (c73 0) vsource dc=0.8
Vg74 (c74 0) vsource dc=0.8
Vg75 (c75 0) vsource dc=0.8
Vg76 (c76 0) vsource dc=0.8
Vg77 (c77 0) vsource dc=0.8
Vg78 (c78 0) vsource dc=0.8
Vg79 (c79 0) vsource dc=0.8
Vg80 (c80 0) vsource dc=0.8
Vg81 (c81 0) vsource dc=0.8
Vg82 (c82 0) vsource dc=0.8
Vg83 (c83 0) vsource dc=0.8
Vg84 (c84 0) vsource dc=0.8
Vg85 (c85 0) vsource dc=0.8
Vg86 (c86 0) vsource dc=0.8
Vg87 (c87 0) vsource dc=0.8
Vg88 (c88 0) vsource dc=0.8
Vg89 (c89 0) vsource dc=0.8
Vg90 (c90 0) vsource dc=0.8
Vg91 (c91 0) vsource dc=0.8
Vg92 (c92 0) vsource dc=0.8
Vg93 (c93 0) vsource dc=0.8
Vg94 (c94 0) vsource dc=0.8
Vg95 (c95 0) vsource dc=0.8
Vg96 (c96 0) vsource dc=0.8
Vg97 (c97 0) vsource dc=0.8
Vg98 (c98 0) vsource dc=0.8
Vg99 (c99 0) vsource dc=0.8
Vg100 (c100 0) vsource dc=0.8
Vg101 (c101 0) vsource dc=0.8
Vg102 (c102 0) vsource dc=0.8
Vg103 (c103 0) vsource dc=0.8
Vg104 (c104 0) vsource dc=0.8
Vg105 (c105 0) vsource dc=0.8
Vg106 (c106 0) vsource dc=0.8
Vg107 (c107 0) vsource dc=0.8
Vg108 (c108 0) vsource dc=0.8
Vg109 (c109 0) vsource dc=0.8
Vg110 (c110 0) vsource dc=0.8
Vg111 (c111 0) vsource dc=0.8
Vg112 (c112 0) vsource dc=0.8
Vg113 (c113 0) vsource dc=0.8
Vg114 (c114 0) vsource dc=0.8
Vg115 (c115 0) vsource dc=0.8
Vg116 (c116 0) vsource dc=0.8
Vg117 (c117 0) vsource dc=0.8
Vg118 (c118 0) vsource dc=0.8
Vg119 (c119 0) vsource dc=0.8
Vg120 (c120 0) vsource dc=0.8
Vg121 (c121 0) vsource dc=0.8
Vg122 (c122 0) vsource dc=0.8
Vg123 (c123 0) vsource dc=0.8
Vg124 (c124 0) vsource dc=0.8
Vg125 (c125 0) vsource dc=0.8
Vg126 (c126 0) vsource dc=0.8
Vg127 (c127 0) vsource dc=0.8
Vg128 (c128 0) vsource dc=0.8
Vg129 (c129 0) vsource dc=0.8
Vg130 (c130 0) vsource dc=0.8
Vg131 (c131 0) vsource dc=0.8
Vg132 (c132 0) vsource dc=0.8
Vg133 (c133 0) vsource dc=0.8
Vg134 (c134 0) vsource dc=0.8
Vg135 (c135 0) vsource dc=0.8
Vg136 (c136 0) vsource dc=0.8
Vg137 (c137 0) vsource dc=0.8
Vg138 (c138 0) vsource dc=0.8
Vg139 (c139 0) vsource dc=0.8
Vg140 (c140 0) vsource dc=0.8
Vg141 (c141 0) vsource dc=0.8
Vg142 (c142 0) vsource dc=0.8
Vg143 (c143 0) vsource dc=0.8
Vg144 (c144 0) vsource dc=0.8
Vg145 (c145 0) vsource dc=0.8
Vg146 (c146 0) vsource dc=0.8
Vg147 (c147 0) vsource dc=0.8
Vg148 (c148 0) vsource dc=0.8
Vg149 (c149 0) vsource dc=0.8
Vg150 (c150 0) vsource dc=0.8
Vg151 (c151 0) vsource dc=0.8
Vg152 (c152 0) vsource dc=0.8
Vg153 (c153 0) vsource dc=0.8
Vg154 (c154 0) vsource dc=0.8
Vg155 (c155 0) vsource dc=0.8
Vg156 (c156 0) vsource dc=0.8
Vg157 (c157 0) vsource dc=0.8
Vg158 (c158 0) vsource dc=0.8
Vg159 (c159 0) vsource dc=0.8
Vg160 (c160 0) vsource dc=0.8
Vg161 (c161 0) vsource dc=0.8
Vg162 (c162 0) vsource dc=0.8
Vg163 (c163 0) vsource dc=0.8
Vg164 (c164 0) vsource dc=0.8
Vg165 (c165 0) vsource dc=0.8
Vg166 (c166 0) vsource dc=0.8
Vg167 (c167 0) vsource dc=0.8
Vg168 (c168 0) vsource dc=0.8
Vg169 (c169 0) vsource dc=0.8
Vg170 (c170 0) vsource dc=0.8
Vg171 (c171 0) vsource dc=0.8
Vg172 (c172 0) vsource dc=0.8
Vg173 (c173 0) vsource dc=0.8
Vg174 (c174 0) vsource dc=0.8
Vg175 (c175 0) vsource dc=0.8
Vg176 (c176 0) vsource dc=0.8
Vg177 (c177 0) vsource dc=0.8
Vg178 (c178 0) vsource dc=0.8
Vg179 (c179 0) vsource dc=0.8
Vg180 (c180 0) vsource dc=0.8
Vg181 (c181 0) vsource dc=0.8
Vg182 (c182 0) vsource dc=0.8
Vg183 (c183 0) vsource dc=0.8
Vg184 (c184 0) vsource dc=0.8
Vg185 (c185 0) vsource dc=0.8
Vg186 (c186 0) vsource dc=0.8
Vg187 (c187 0) vsource dc=0.8
Vg188 (c188 0) vsource dc=0.8
Vg189 (c189 0) vsource dc=0.8
Vg190 (c190 0) vsource dc=0.8
Vg191 (c191 0) vsource dc=0.8
Vg192 (c192 0) vsource dc=0.8
Vg193 (c193 0) vsource dc=0.8
Vg194 (c194 0) vsource dc=0.8
Vg195 (c195 0) vsource dc=0.8
Vg196 (c196 0) vsource dc=0.8
Vg197 (c197 0) vsource dc=0.8
Vg198 (c198 0) vsource dc=0.8
Vg199 (c199 0) vsource dc=0.8
Vg200 (c200 0) vsource dc=0.8
Vg201 (c201 0) vsource dc=0.8
Vg202 (c202 0) vsource dc=0.8
Vg203 (c203 0) vsource dc=0.8
Vg204 (c204 0) vsource dc=0.8
Vg205 (c205 0) vsource dc=0.8
Vg206 (c206 0) vsource dc=0.8
Vg207 (c207 0) vsource dc=0.8
Vg208 (c208 0) vsource dc=0.8
Vg209 (c209 0) vsource dc=0.8
Vg210 (c210 0) vsource dc=0.8
Vg211 (c211 0) vsource dc=0.8
Vg212 (c212 0) vsource dc=0.8
Vg213 (c213 0) vsource dc=0.8
Vg214 (c214 0) vsource dc=0.8
Vg215 (c215 0) vsource dc=0.8
Vg216 (c216 0) vsource dc=0.8
Vg217 (c217 0) vsource dc=0.8
Vg218 (c218 0) vsource dc=0.8
Vg219 (c219 0) vsource dc=0.8
Vg220 (c220 0) vsource dc=0.8
Vg221 (c221 0) vsource dc=0.8
Vg222 (c222 0) vsource dc=0.8
Vg223 (c223 0) vsource dc=0.8
Vg224 (c224 0) vsource dc=0.8
Vg225 (c225 0) vsource dc=0.8
Vg226 (c226 0) vsource dc=0.8
Vg227 (c227 0) vsource dc=0.8
Vg228 (c228 0) vsource dc=0.8
Vg229 (c229 0) vsource dc=0.8
Vg230 (c230 0) vsource dc=0.8
Vg231 (c231 0) vsource dc=0.8
Vg232 (c232 0) vsource dc=0.8
Vg233 (c233 0) vsource dc=0.8
Vg234 (c234 0) vsource dc=0.8
Vg235 (c235 0) vsource dc=0.8
Vg236 (c236 0) vsource dc=0.8
Vg237 (c237 0) vsource dc=0.8
Vg238 (c238 0) vsource dc=0.8
Vg239 (c239 0) vsource dc=0.8
Vg240 (c240 0) vsource dc=0.8
Vg241 (c241 0) vsource dc=0.8
Vg242 (c242 0) vsource dc=0.8
Vg243 (c243 0) vsource dc=0.8
Vg244 (c244 0) vsource dc=0.8
Vg245 (c245 0) vsource dc=0.8
Vg246 (c246 0) vsource dc=0.8
Vg247 (c247 0) vsource dc=0.8
Vg248 (c248 0) vsource dc=0.8
Vg249 (c249 0) vsource dc=0.8
Vg250 (c250 0) vsource dc=0.8
Vg251 (c251 0) vsource dc=0.8
Vg252 (c252 0) vsource dc=0.8
Vg253 (c253 0) vsource dc=0.8
Vg254 (c254 0) vsource dc=0.8
Vg255 (c255 0) vsource dc=0.8
Vg256 (c256 0) vsource dc=0.8
Vg257 (c257 0) vsource dc=0.8
Vg258 (c258 0) vsource dc=0.8
Vg259 (c259 0) vsource dc=0.8
Vg260 (c260 0) vsource dc=0.8
Vg261 (c261 0) vsource dc=0.8
Vg262 (c262 0) vsource dc=0.8
Vg263 (c263 0) vsource dc=0.8
Vg264 (c264 0) vsource dc=0.8
Vg265 (c265 0) vsource dc=0.8
Vg266 (c266 0) vsource dc=0.8
Vg267 (c267 0) vsource dc=0.8
Vg268 (c268 0) vsource dc=0.8
Vg269 (c269 0) vsource dc=0.8
Vg270 (c270 0) vsource dc=0.8
Vg271 (c271 0) vsource dc=0.8
Vg272 (c272 0) vsource dc=0.8
Vg273 (c273 0) vsource dc=0.8
Vg274 (c274 0) vsource dc=0.8
Vg275 (c275 0) vsource dc=0.8
Vg276 (c276 0) vsource dc=0.8
Vg277 (c277 0) vsource dc=0.8
Vg278 (c278 0) vsource dc=0.8
Vg279 (c279 0) vsource dc=0.8
Vg280 (c280 0) vsource dc=0.8
Vg281 (c281 0) vsource dc=0.8
Vg282 (c282 0) vsource dc=0.8
Vg283 (c283 0) vsource dc=0.8
Vg284 (c284 0) vsource dc=0.8
Vg285 (c285 0) vsource dc=0.8
Vg286 (c286 0) vsource dc=0.8
Vg287 (c287 0) vsource dc=0.8
Vg288 (c288 0) vsource dc=0.8
Vg289 (c289 0) vsource dc=0.8
Vg290 (c290 0) vsource dc=0.8
Vg291 (c291 0) vsource dc=0.8
Vg292 (c292 0) vsource dc=0.8
Vg293 (c293 0) vsource dc=0.8
Vg294 (c294 0) vsource dc=0.8
Vg295 (c295 0) vsource dc=0.8
Vg296 (c296 0) vsource dc=0.8
Vg297 (c297 0) vsource dc=0.8
Vg298 (c298 0) vsource dc=0.8
Vg299 (c299 0) vsource dc=0.8
Vg300 (c300 0) vsource dc=0.8
Vg301 (c301 0) vsource dc=0.8
Vg302 (c302 0) vsource dc=0.8
Vg303 (c303 0) vsource dc=0.8
Vg304 (c304 0) vsource dc=0.8
Vg305 (c305 0) vsource dc=0.8
Vg306 (c306 0) vsource dc=0.8
Vg307 (c307 0) vsource dc=0.8
Vg308 (c308 0) vsource dc=0.8
Vg309 (c309 0) vsource dc=0.8
Vg310 (c310 0) vsource dc=0.8
Vg311 (c311 0) vsource dc=0.8
Vg312 (c312 0) vsource dc=0.8
Vg313 (c313 0) vsource dc=0.8
Vg314 (c314 0) vsource dc=0.8
Vg315 (c315 0) vsource dc=0.8
Vg316 (c316 0) vsource dc=0.8
Vg317 (c317 0) vsource dc=0.8
Vg318 (c318 0) vsource dc=0.8
Vg319 (c319 0) vsource dc=0.8
Vg320 (c320 0) vsource dc=0.8
Vg321 (c321 0) vsource dc=0.8
Vg322 (c322 0) vsource dc=0.8
Vg323 (c323 0) vsource dc=0.8
Vg324 (c324 0) vsource dc=0.8
Vg325 (c325 0) vsource dc=0.8
Vg326 (c326 0) vsource dc=0.8
Vg327 (c327 0) vsource dc=0.8
Vg328 (c328 0) vsource dc=0.8
Vg329 (c329 0) vsource dc=0.8
Vg330 (c330 0) vsource dc=0.8
Vg331 (c331 0) vsource dc=0.8
Vg332 (c332 0) vsource dc=0.8
Vg333 (c333 0) vsource dc=0.8
Vg334 (c334 0) vsource dc=0.8
Vg335 (c335 0) vsource dc=0.8
Vg336 (c336 0) vsource dc=0.8
Vg337 (c337 0) vsource dc=0.8
Vg338 (c338 0) vsource dc=0.8
Vg339 (c339 0) vsource dc=0.8
Vg340 (c340 0) vsource dc=0.8
Vg341 (c341 0) vsource dc=0.8
Vg342 (c342 0) vsource dc=0.8
Vg343 (c343 0) vsource dc=0.8
Vg344 (c344 0) vsource dc=0.8
Vg345 (c345 0) vsource dc=0.8
Vg346 (c346 0) vsource dc=0.8
Vg347 (c347 0) vsource dc=0.8
Vg348 (c348 0) vsource dc=0.8
Vg349 (c349 0) vsource dc=0.8
Vg350 (c350 0) vsource dc=0.8
Vg351 (c351 0) vsource dc=0.8
Vg352 (c352 0) vsource dc=0.8
Vg353 (c353 0) vsource dc=0.8
Vg354 (c354 0) vsource dc=0.8
Vg355 (c355 0) vsource dc=0.8
Vg356 (c356 0) vsource dc=0.8
Vg357 (c357 0) vsource dc=0.8
Vg358 (c358 0) vsource dc=0.8
Vg359 (c359 0) vsource dc=0.8
Vg360 (c360 0) vsource dc=0.8
Vg361 (c361 0) vsource dc=0.8
Vg362 (c362 0) vsource dc=0.8
Vg363 (c363 0) vsource dc=0.8
Vg364 (c364 0) vsource dc=0.8
Vg365 (c365 0) vsource dc=0.8
Vg366 (c366 0) vsource dc=0.8
Vg367 (c367 0) vsource dc=0.8
Vg368 (c368 0) vsource dc=0.8
Vg369 (c369 0) vsource dc=0.8
Vg370 (c370 0) vsource dc=0.8
Vg371 (c371 0) vsource dc=0.8
Vg372 (c372 0) vsource dc=0.8
Vg373 (c373 0) vsource dc=0.8
Vg374 (c374 0) vsource dc=0.8
Vg375 (c375 0) vsource dc=0.8
Vg376 (c376 0) vsource dc=0.8
Vg377 (c377 0) vsource dc=0.8
Vg378 (c378 0) vsource dc=0.8
Vg379 (c379 0) vsource dc=0.8
Vg380 (c380 0) vsource dc=0.8
Vg381 (c381 0) vsource dc=0.8
Vg382 (c382 0) vsource dc=0.8
Vg383 (c383 0) vsource dc=0.8
Vg384 (c384 0) vsource dc=0.8
Vg385 (c385 0) vsource dc=0.8
Vg386 (c386 0) vsource dc=0.8
Vg387 (c387 0) vsource dc=0.8
Vg388 (c388 0) vsource dc=0.8
Vg389 (c389 0) vsource dc=0.8
Vg390 (c390 0) vsource dc=0.8
Vg391 (c391 0) vsource dc=0.8
Vg392 (c392 0) vsource dc=0.8
Vg393 (c393 0) vsource dc=0.8
Vg394 (c394 0) vsource dc=0.8
Vg395 (c395 0) vsource dc=0.8
Vg396 (c396 0) vsource dc=0.8
Vg397 (c397 0) vsource dc=0.8
Vg398 (c398 0) vsource dc=0.8
Vg399 (c399 0) vsource dc=0.8
Vg400 (c400 0) vsource dc=0.8
Vg401 (c401 0) vsource dc=0.8
Vg402 (c402 0) vsource dc=0.8
Vg403 (c403 0) vsource dc=0.8
Vg404 (c404 0) vsource dc=0.8
Vg405 (c405 0) vsource dc=0.8
Vg406 (c406 0) vsource dc=0.8
Vg407 (c407 0) vsource dc=0.8
Vg408 (c408 0) vsource dc=0.8
Vg409 (c409 0) vsource dc=0.8
Vg410 (c410 0) vsource dc=0.8
Vg411 (c411 0) vsource dc=0.8
Vg412 (c412 0) vsource dc=0.8
Vg413 (c413 0) vsource dc=0.8
Vg414 (c414 0) vsource dc=0.8
Vg415 (c415 0) vsource dc=0.8
Vg416 (c416 0) vsource dc=0.8
Vg417 (c417 0) vsource dc=0.8
Vg418 (c418 0) vsource dc=0.8
Vg419 (c419 0) vsource dc=0.8
Vg420 (c420 0) vsource dc=0.8
Vg421 (c421 0) vsource dc=0.8
Vg422 (c422 0) vsource dc=0.8
Vg423 (c423 0) vsource dc=0.8
Vg424 (c424 0) vsource dc=0.8
Vg425 (c425 0) vsource dc=0.8
Vg426 (c426 0) vsource dc=0.8
Vg427 (c427 0) vsource dc=0.8
Vg428 (c428 0) vsource dc=0.8
Vg429 (c429 0) vsource dc=0.8
Vg430 (c430 0) vsource dc=0.8
Vg431 (c431 0) vsource dc=0.8
Vg432 (c432 0) vsource dc=0.8
Vg433 (c433 0) vsource dc=0.8
Vg434 (c434 0) vsource dc=0.8
Vg435 (c435 0) vsource dc=0.8
Vg436 (c436 0) vsource dc=0.8
Vg437 (c437 0) vsource dc=0.8
Vg438 (c438 0) vsource dc=0.8
Vg439 (c439 0) vsource dc=0.8
Vg440 (c440 0) vsource dc=0.8
Vg441 (c441 0) vsource dc=0.8
Vg442 (c442 0) vsource dc=0.8
Vg443 (c443 0) vsource dc=0.8
Vg444 (c444 0) vsource dc=0.8
Vg445 (c445 0) vsource dc=0.8
Vg446 (c446 0) vsource dc=0.8
Vg447 (c447 0) vsource dc=0.8
Vg448 (c448 0) vsource dc=0.0
Vg449 (c449 0) vsource dc=0.0
Vg450 (c450 0) vsource dc=0.0
Vg451 (c451 0) vsource dc=0.0
Vg452 (c452 0) vsource dc=0.0
Vg453 (c453 0) vsource dc=0.0
Vg454 (c454 0) vsource dc=0.0
Vg455 (c455 0) vsource dc=0.0
Vg456 (c456 0) vsource dc=0.0
Vg457 (c457 0) vsource dc=0.0
Vg458 (c458 0) vsource dc=0.0
Vg459 (c459 0) vsource dc=0.0
Vg460 (c460 0) vsource dc=0.0
Vg461 (c461 0) vsource dc=0.0
Vg462 (c462 0) vsource dc=0.0
Vg463 (c463 0) vsource dc=0.0
Vg464 (c464 0) vsource dc=0.0
Vg465 (c465 0) vsource dc=0.0
Vg466 (c466 0) vsource dc=0.0
Vg467 (c467 0) vsource dc=0.0
Vg468 (c468 0) vsource dc=0.0
Vg469 (c469 0) vsource dc=0.0
Vg470 (c470 0) vsource dc=0.0
Vg471 (c471 0) vsource dc=0.0
Vg472 (c472 0) vsource dc=0.0
Vg473 (c473 0) vsource dc=0.0
Vg474 (c474 0) vsource dc=0.0
Vg475 (c475 0) vsource dc=0.0
Vg476 (c476 0) vsource dc=0.0
Vg477 (c477 0) vsource dc=0.0
Vg478 (c478 0) vsource dc=0.0
Vg479 (c479 0) vsource dc=0.0
Vg480 (c480 0) vsource dc=0.0
Vg481 (c481 0) vsource dc=0.0
Vg482 (c482 0) vsource dc=0.0
Vg483 (c483 0) vsource dc=0.0
Vg484 (c484 0) vsource dc=0.0
Vg485 (c485 0) vsource dc=0.0
Vg486 (c486 0) vsource dc=0.0
Vg487 (c487 0) vsource dc=0.0
Vg488 (c488 0) vsource dc=0.0
Vg489 (c489 0) vsource dc=0.0
Vg490 (c490 0) vsource dc=0.0
Vg491 (c491 0) vsource dc=0.0
Vg492 (c492 0) vsource dc=0.0
Vg493 (c493 0) vsource dc=0.0
Vg494 (c494 0) vsource dc=0.0
Vg495 (c495 0) vsource dc=0.0
Vg496 (c496 0) vsource dc=0.0
Vg497 (c497 0) vsource dc=0.0
Vg498 (c498 0) vsource dc=0.0
Vg499 (c499 0) vsource dc=0.0
Vg500 (c500 0) vsource dc=0.0
Vg501 (c501 0) vsource dc=0.0
Vg502 (c502 0) vsource dc=0.0
Vg503 (c503 0) vsource dc=0.0
Vg504 (c504 0) vsource dc=0.0
Vg505 (c505 0) vsource dc=0.0
Vg506 (c506 0) vsource dc=0.0
Vg507 (c507 0) vsource dc=0.0
Vg508 (c508 0) vsource dc=0.0
Vg509 (c509 0) vsource dc=0.0
Vg510 (c510 0) vsource dc=0.0
Vg511 (c511 0) vsource dc=0.0
Vg512 (c512 0) vsource dc=0.0
Vg513 (c513 0) vsource dc=0.0
Vg514 (c514 0) vsource dc=0.0
Vg515 (c515 0) vsource dc=0.0
Vg516 (c516 0) vsource dc=0.0
Vg517 (c517 0) vsource dc=0.0
Vg518 (c518 0) vsource dc=0.0
Vg519 (c519 0) vsource dc=0.0
Vg520 (c520 0) vsource dc=0.0
Vg521 (c521 0) vsource dc=0.0
Vg522 (c522 0) vsource dc=0.0
Vg523 (c523 0) vsource dc=0.0
Vg524 (c524 0) vsource dc=0.0
Vg525 (c525 0) vsource dc=0.0
Vg526 (c526 0) vsource dc=0.0
Vg527 (c527 0) vsource dc=0.0
Vg528 (c528 0) vsource dc=0.0
Vg529 (c529 0) vsource dc=0.0
Vg530 (c530 0) vsource dc=0.0
Vg531 (c531 0) vsource dc=0.0
Vg532 (c532 0) vsource dc=0.0
Vg533 (c533 0) vsource dc=0.0
Vg534 (c534 0) vsource dc=0.0
Vg535 (c535 0) vsource dc=0.0
Vg536 (c536 0) vsource dc=0.0
Vg537 (c537 0) vsource dc=0.0
Vg538 (c538 0) vsource dc=0.0
Vg539 (c539 0) vsource dc=0.0
Vg540 (c540 0) vsource dc=0.0
Vg541 (c541 0) vsource dc=0.0
Vg542 (c542 0) vsource dc=0.0
Vg543 (c543 0) vsource dc=0.0
Vg544 (c544 0) vsource dc=0.0
Vg545 (c545 0) vsource dc=0.0
Vg546 (c546 0) vsource dc=0.0
Vg547 (c547 0) vsource dc=0.0
Vg548 (c548 0) vsource dc=0.0
Vg549 (c549 0) vsource dc=0.0
Vg550 (c550 0) vsource dc=0.0
Vg551 (c551 0) vsource dc=0.0
Vg552 (c552 0) vsource dc=0.0
Vg553 (c553 0) vsource dc=0.0
Vg554 (c554 0) vsource dc=0.0
Vg555 (c555 0) vsource dc=0.0
Vg556 (c556 0) vsource dc=0.0
Vg557 (c557 0) vsource dc=0.0
Vg558 (c558 0) vsource dc=0.0
Vg559 (c559 0) vsource dc=0.0
Vg560 (c560 0) vsource dc=0.0
Vg561 (c561 0) vsource dc=0.0
Vg562 (c562 0) vsource dc=0.0
Vg563 (c563 0) vsource dc=0.0
Vg564 (c564 0) vsource dc=0.0
Vg565 (c565 0) vsource dc=0.0
Vg566 (c566 0) vsource dc=0.0
Vg567 (c567 0) vsource dc=0.0
Vg568 (c568 0) vsource dc=0.0
Vg569 (c569 0) vsource dc=0.0
Vg570 (c570 0) vsource dc=0.0
Vg571 (c571 0) vsource dc=0.0
Vg572 (c572 0) vsource dc=0.0
Vg573 (c573 0) vsource dc=0.0
Vg574 (c574 0) vsource dc=0.0
Vg575 (c575 0) vsource dc=0.0
Vg576 (c576 0) vsource dc=0.0
Vg577 (c577 0) vsource dc=0.0
Vg578 (c578 0) vsource dc=0.0
Vg579 (c579 0) vsource dc=0.0
Vg580 (c580 0) vsource dc=0.0
Vg581 (c581 0) vsource dc=0.0
Vg582 (c582 0) vsource dc=0.0
Vg583 (c583 0) vsource dc=0.0
Vg584 (c584 0) vsource dc=0.0
Vg585 (c585 0) vsource dc=0.0
Vg586 (c586 0) vsource dc=0.0
Vg587 (c587 0) vsource dc=0.0
Vg588 (c588 0) vsource dc=0.0
Vg589 (c589 0) vsource dc=0.0
Vg590 (c590 0) vsource dc=0.0
Vg591 (c591 0) vsource dc=0.0
Vg592 (c592 0) vsource dc=0.0
Vg593 (c593 0) vsource dc=0.0
Vg594 (c594 0) vsource dc=0.0
Vg595 (c595 0) vsource dc=0.0
Vg596 (c596 0) vsource dc=0.0
Vg597 (c597 0) vsource dc=0.0
Vg598 (c598 0) vsource dc=0.0
Vg599 (c599 0) vsource dc=0.0
Vg600 (c600 0) vsource dc=0.0
Vg601 (c601 0) vsource dc=0.0
Vg602 (c602 0) vsource dc=0.0
Vg603 (c603 0) vsource dc=0.0
Vg604 (c604 0) vsource dc=0.0
Vg605 (c605 0) vsource dc=0.0
Vg606 (c606 0) vsource dc=0.0
Vg607 (c607 0) vsource dc=0.0
Vg608 (c608 0) vsource dc=0.0
Vg609 (c609 0) vsource dc=0.0
Vg610 (c610 0) vsource dc=0.0
Vg611 (c611 0) vsource dc=0.0
Vg612 (c612 0) vsource dc=0.0
Vg613 (c613 0) vsource dc=0.0
Vg614 (c614 0) vsource dc=0.0
Vg615 (c615 0) vsource dc=0.0
Vg616 (c616 0) vsource dc=0.0
Vg617 (c617 0) vsource dc=0.0
Vg618 (c618 0) vsource dc=0.0
Vg619 (c619 0) vsource dc=0.0
Vg620 (c620 0) vsource dc=0.0
Vg621 (c621 0) vsource dc=0.0
Vg622 (c622 0) vsource dc=0.0
Vg623 (c623 0) vsource dc=0.0
Vg624 (c624 0) vsource dc=0.0
Vg625 (c625 0) vsource dc=0.0
Vg626 (c626 0) vsource dc=0.0
Vg627 (c627 0) vsource dc=0.0
Vg628 (c628 0) vsource dc=0.0
Vg629 (c629 0) vsource dc=0.0
Vg630 (c630 0) vsource dc=0.0
Vg631 (c631 0) vsource dc=0.0
Vg632 (c632 0) vsource dc=0.0
Vg633 (c633 0) vsource dc=0.0
Vg634 (c634 0) vsource dc=0.0
Vg635 (c635 0) vsource dc=0.0
Vg636 (c636 0) vsource dc=0.0
Vg637 (c637 0) vsource dc=0.0
Vg638 (c638 0) vsource dc=0.0
Vg639 (c639 0) vsource dc=0.0
Vg640 (c640 0) vsource dc=0.0
Vg641 (c641 0) vsource dc=0.0
Vg642 (c642 0) vsource dc=0.0
Vg643 (c643 0) vsource dc=0.0
Vg644 (c644 0) vsource dc=0.0
Vg645 (c645 0) vsource dc=0.0
Vg646 (c646 0) vsource dc=0.0
Vg647 (c647 0) vsource dc=0.0
Vg648 (c648 0) vsource dc=0.0
Vg649 (c649 0) vsource dc=0.0
Vg650 (c650 0) vsource dc=0.0
Vg651 (c651 0) vsource dc=0.0
Vg652 (c652 0) vsource dc=0.0
Vg653 (c653 0) vsource dc=0.0
Vg654 (c654 0) vsource dc=0.0
Vg655 (c655 0) vsource dc=0.0
Vg656 (c656 0) vsource dc=0.0
Vg657 (c657 0) vsource dc=0.0
Vg658 (c658 0) vsource dc=0.0
Vg659 (c659 0) vsource dc=0.0
Vg660 (c660 0) vsource dc=0.0
Vg661 (c661 0) vsource dc=0.0
Vg662 (c662 0) vsource dc=0.0
Vg663 (c663 0) vsource dc=0.0
Vg664 (c664 0) vsource dc=0.0
Vg665 (c665 0) vsource dc=0.0
Vg666 (c666 0) vsource dc=0.0
Vg667 (c667 0) vsource dc=0.0
Vg668 (c668 0) vsource dc=0.0
Vg669 (c669 0) vsource dc=0.0
Vg670 (c670 0) vsource dc=0.0
Vg671 (c671 0) vsource dc=0.0
Vg672 (c672 0) vsource dc=0.0
Vg673 (c673 0) vsource dc=0.0
Vg674 (c674 0) vsource dc=0.0
Vg675 (c675 0) vsource dc=0.0
Vg676 (c676 0) vsource dc=0.0
Vg677 (c677 0) vsource dc=0.0
Vg678 (c678 0) vsource dc=0.0
Vg679 (c679 0) vsource dc=0.0
Vg680 (c680 0) vsource dc=0.0
Vg681 (c681 0) vsource dc=0.0
Vg682 (c682 0) vsource dc=0.0
Vg683 (c683 0) vsource dc=0.0
Vg684 (c684 0) vsource dc=0.0
Vg685 (c685 0) vsource dc=0.0
Vg686 (c686 0) vsource dc=0.0
Vg687 (c687 0) vsource dc=0.0
Vg688 (c688 0) vsource dc=0.0
Vg689 (c689 0) vsource dc=0.0
Vg690 (c690 0) vsource dc=0.0
Vg691 (c691 0) vsource dc=0.0
Vg692 (c692 0) vsource dc=0.0
Vg693 (c693 0) vsource dc=0.0
Vg694 (c694 0) vsource dc=0.0
Vg695 (c695 0) vsource dc=0.0
Vg696 (c696 0) vsource dc=0.0
Vg697 (c697 0) vsource dc=0.0
Vg698 (c698 0) vsource dc=0.0
Vg699 (c699 0) vsource dc=0.0
Vg700 (c700 0) vsource dc=0.0
Vg701 (c701 0) vsource dc=0.0
Vg702 (c702 0) vsource dc=0.0
Vg703 (c703 0) vsource dc=0.0
Vg704 (c704 0) vsource dc=0.0
Vg705 (c705 0) vsource dc=0.0
Vg706 (c706 0) vsource dc=0.0
Vg707 (c707 0) vsource dc=0.0
Vg708 (c708 0) vsource dc=0.0
Vg709 (c709 0) vsource dc=0.0
Vg710 (c710 0) vsource dc=0.0
Vg711 (c711 0) vsource dc=0.0
Vg712 (c712 0) vsource dc=0.0
Vg713 (c713 0) vsource dc=0.0
Vg714 (c714 0) vsource dc=0.0
Vg715 (c715 0) vsource dc=0.0
Vg716 (c716 0) vsource dc=0.0
Vg717 (c717 0) vsource dc=0.0
Vg718 (c718 0) vsource dc=0.0
Vg719 (c719 0) vsource dc=0.0
Vg720 (c720 0) vsource dc=0.0
Vg721 (c721 0) vsource dc=0.0
Vg722 (c722 0) vsource dc=0.0
Vg723 (c723 0) vsource dc=0.0
Vg724 (c724 0) vsource dc=0.0
Vg725 (c725 0) vsource dc=0.0
Vg726 (c726 0) vsource dc=0.0
Vg727 (c727 0) vsource dc=0.0
Vg728 (c728 0) vsource dc=0.0
Vg729 (c729 0) vsource dc=0.0
Vg730 (c730 0) vsource dc=0.0
Vg731 (c731 0) vsource dc=0.0
Vg732 (c732 0) vsource dc=0.0
Vg733 (c733 0) vsource dc=0.0
Vg734 (c734 0) vsource dc=0.0
Vg735 (c735 0) vsource dc=0.0
Vg736 (c736 0) vsource dc=0.0
Vg737 (c737 0) vsource dc=0.0
Vg738 (c738 0) vsource dc=0.0
Vg739 (c739 0) vsource dc=0.0
Vg740 (c740 0) vsource dc=0.0
Vg741 (c741 0) vsource dc=0.0
Vg742 (c742 0) vsource dc=0.0
Vg743 (c743 0) vsource dc=0.0
Vg744 (c744 0) vsource dc=0.0
Vg745 (c745 0) vsource dc=0.0
Vg746 (c746 0) vsource dc=0.0
Vg747 (c747 0) vsource dc=0.0
Vg748 (c748 0) vsource dc=0.0
Vg749 (c749 0) vsource dc=0.0
Vg750 (c750 0) vsource dc=0.0
Vg751 (c751 0) vsource dc=0.0
Vg752 (c752 0) vsource dc=0.0
Vg753 (c753 0) vsource dc=0.0
Vg754 (c754 0) vsource dc=0.0
Vg755 (c755 0) vsource dc=0.0
Vg756 (c756 0) vsource dc=0.0
Vg757 (c757 0) vsource dc=0.0
Vg758 (c758 0) vsource dc=0.0
Vg759 (c759 0) vsource dc=0.0
Vg760 (c760 0) vsource dc=0.0
Vg761 (c761 0) vsource dc=0.0
Vg762 (c762 0) vsource dc=0.0
Vg763 (c763 0) vsource dc=0.0
Vg764 (c764 0) vsource dc=0.0
Vg765 (c765 0) vsource dc=0.0
Vg766 (c766 0) vsource dc=0.0
Vg767 (c767 0) vsource dc=0.0
Vg768 (c768 0) vsource dc=0.0
Vg769 (c769 0) vsource dc=0.0
Vg770 (c770 0) vsource dc=0.0
Vg771 (c771 0) vsource dc=0.0
Vg772 (c772 0) vsource dc=0.0
Vg773 (c773 0) vsource dc=0.0
Vg774 (c774 0) vsource dc=0.0
Vg775 (c775 0) vsource dc=0.0
Vg776 (c776 0) vsource dc=0.0
Vg777 (c777 0) vsource dc=0.0
Vg778 (c778 0) vsource dc=0.0
Vg779 (c779 0) vsource dc=0.0
Vg780 (c780 0) vsource dc=0.0
Vg781 (c781 0) vsource dc=0.0
Vg782 (c782 0) vsource dc=0.0
Vg783 (c783 0) vsource dc=0.0
Vg784 (c784 0) vsource dc=0.0
Vg785 (c785 0) vsource dc=0.0
Vg786 (c786 0) vsource dc=0.0
Vg787 (c787 0) vsource dc=0.0
Vg788 (c788 0) vsource dc=0.0
Vg789 (c789 0) vsource dc=0.0
Vg790 (c790 0) vsource dc=0.0
Vg791 (c791 0) vsource dc=0.0
Vg792 (c792 0) vsource dc=0.0
Vg793 (c793 0) vsource dc=0.0
Vg794 (c794 0) vsource dc=0.0
Vg795 (c795 0) vsource dc=0.0
Vg796 (c796 0) vsource dc=0.0
Vg797 (c797 0) vsource dc=0.0
Vg798 (c798 0) vsource dc=0.0
Vg799 (c799 0) vsource dc=0.0
Vg800 (c800 0) vsource dc=0.0
Vg801 (c801 0) vsource dc=0.0
Vg802 (c802 0) vsource dc=0.0
Vg803 (c803 0) vsource dc=0.0
Vg804 (c804 0) vsource dc=0.0
Vg805 (c805 0) vsource dc=0.0
Vg806 (c806 0) vsource dc=0.0
Vg807 (c807 0) vsource dc=0.0
Vg808 (c808 0) vsource dc=0.0
Vg809 (c809 0) vsource dc=0.0
Vg810 (c810 0) vsource dc=0.0
Vg811 (c811 0) vsource dc=0.0
Vg812 (c812 0) vsource dc=0.0
Vg813 (c813 0) vsource dc=0.0
Vg814 (c814 0) vsource dc=0.0
Vg815 (c815 0) vsource dc=0.0
Vg816 (c816 0) vsource dc=0.0
Vg817 (c817 0) vsource dc=0.0
Vg818 (c818 0) vsource dc=0.0
Vg819 (c819 0) vsource dc=0.0
Vg820 (c820 0) vsource dc=0.0
Vg821 (c821 0) vsource dc=0.0
Vg822 (c822 0) vsource dc=0.0
Vg823 (c823 0) vsource dc=0.0
Vg824 (c824 0) vsource dc=0.0
Vg825 (c825 0) vsource dc=0.0
Vg826 (c826 0) vsource dc=0.0
Vg827 (c827 0) vsource dc=0.0
Vg828 (c828 0) vsource dc=0.0
Vg829 (c829 0) vsource dc=0.0
Vg830 (c830 0) vsource dc=0.0
Vg831 (c831 0) vsource dc=0.0
Vg832 (c832 0) vsource dc=0.0
Vg833 (c833 0) vsource dc=0.0
Vg834 (c834 0) vsource dc=0.0
Vg835 (c835 0) vsource dc=0.0
Vg836 (c836 0) vsource dc=0.0
Vg837 (c837 0) vsource dc=0.0
Vg838 (c838 0) vsource dc=0.0
Vg839 (c839 0) vsource dc=0.0
Vg840 (c840 0) vsource dc=0.0
Vg841 (c841 0) vsource dc=0.0
Vg842 (c842 0) vsource dc=0.0
Vg843 (c843 0) vsource dc=0.0
Vg844 (c844 0) vsource dc=0.0
Vg845 (c845 0) vsource dc=0.0
Vg846 (c846 0) vsource dc=0.0
Vg847 (c847 0) vsource dc=0.0
Vg848 (c848 0) vsource dc=0.0
Vg849 (c849 0) vsource dc=0.0
Vg850 (c850 0) vsource dc=0.0
Vg851 (c851 0) vsource dc=0.0
Vg852 (c852 0) vsource dc=0.0
Vg853 (c853 0) vsource dc=0.0
Vg854 (c854 0) vsource dc=0.0
Vg855 (c855 0) vsource dc=0.0
Vg856 (c856 0) vsource dc=0.0
Vg857 (c857 0) vsource dc=0.0
Vg858 (c858 0) vsource dc=0.0
Vg859 (c859 0) vsource dc=0.0
Vg860 (c860 0) vsource dc=0.0
Vg861 (c861 0) vsource dc=0.0
Vg862 (c862 0) vsource dc=0.0
Vg863 (c863 0) vsource dc=0.0
Vg864 (c864 0) vsource dc=0.0
Vg865 (c865 0) vsource dc=0.0
Vg866 (c866 0) vsource dc=0.0
Vg867 (c867 0) vsource dc=0.0
Vg868 (c868 0) vsource dc=0.0
Vg869 (c869 0) vsource dc=0.0
Vg870 (c870 0) vsource dc=0.0
Vg871 (c871 0) vsource dc=0.0
Vg872 (c872 0) vsource dc=0.0
Vg873 (c873 0) vsource dc=0.0
Vg874 (c874 0) vsource dc=0.0
Vg875 (c875 0) vsource dc=0.0
Vg876 (c876 0) vsource dc=0.0
Vg877 (c877 0) vsource dc=0.0
Vg878 (c878 0) vsource dc=0.0
Vg879 (c879 0) vsource dc=0.0
Vg880 (c880 0) vsource dc=0.0
Vg881 (c881 0) vsource dc=0.0
Vg882 (c882 0) vsource dc=0.0
Vg883 (c883 0) vsource dc=0.0
Vg884 (c884 0) vsource dc=0.0
Vg885 (c885 0) vsource dc=0.0
Vg886 (c886 0) vsource dc=0.0
Vg887 (c887 0) vsource dc=0.0
Vg888 (c888 0) vsource dc=0.0
Vg889 (c889 0) vsource dc=0.0
Vg890 (c890 0) vsource dc=0.0
Vg891 (c891 0) vsource dc=0.0
Vg892 (c892 0) vsource dc=0.0
Vg893 (c893 0) vsource dc=0.0
Vg894 (c894 0) vsource dc=0.0
Vg895 (c895 0) vsource dc=0.0
Vg896 (c896 0) vsource dc=0.0
Vg897 (c897 0) vsource dc=0.0
Vg898 (c898 0) vsource dc=0.0
Vg899 (c899 0) vsource dc=0.0
Vg900 (c900 0) vsource dc=0.0
Vg901 (c901 0) vsource dc=0.0
Vg902 (c902 0) vsource dc=0.0
Vg903 (c903 0) vsource dc=0.0
Vg904 (c904 0) vsource dc=0.0
Vg905 (c905 0) vsource dc=0.0
Vg906 (c906 0) vsource dc=0.0
Vg907 (c907 0) vsource dc=0.0
Vg908 (c908 0) vsource dc=0.0
Vg909 (c909 0) vsource dc=0.0
Vg910 (c910 0) vsource dc=0.0
Vg911 (c911 0) vsource dc=0.0
Vg912 (c912 0) vsource dc=0.0
Vg913 (c913 0) vsource dc=0.0
Vg914 (c914 0) vsource dc=0.0
Vg915 (c915 0) vsource dc=0.0
Vg916 (c916 0) vsource dc=0.0
Vg917 (c917 0) vsource dc=0.0
Vg918 (c918 0) vsource dc=0.0
Vg919 (c919 0) vsource dc=0.0
Vg920 (c920 0) vsource dc=0.0
Vg921 (c921 0) vsource dc=0.0
Vg922 (c922 0) vsource dc=0.0
Vg923 (c923 0) vsource dc=0.0
Vg924 (c924 0) vsource dc=0.0
Vg925 (c925 0) vsource dc=0.0
Vg926 (c926 0) vsource dc=0.0
Vg927 (c927 0) vsource dc=0.0
Vg928 (c928 0) vsource dc=0.0
Vg929 (c929 0) vsource dc=0.0
Vg930 (c930 0) vsource dc=0.0
Vg931 (c931 0) vsource dc=0.0
Vg932 (c932 0) vsource dc=0.0
Vg933 (c933 0) vsource dc=0.0
Vg934 (c934 0) vsource dc=0.0
Vg935 (c935 0) vsource dc=0.0
Vg936 (c936 0) vsource dc=0.0
Vg937 (c937 0) vsource dc=0.0
Vg938 (c938 0) vsource dc=0.0
Vg939 (c939 0) vsource dc=0.0
Vg940 (c940 0) vsource dc=0.0
Vg941 (c941 0) vsource dc=0.0
Vg942 (c942 0) vsource dc=0.0
Vg943 (c943 0) vsource dc=0.0
Vg944 (c944 0) vsource dc=0.0
Vg945 (c945 0) vsource dc=0.0
Vg946 (c946 0) vsource dc=0.0
Vg947 (c947 0) vsource dc=0.0
Vg948 (c948 0) vsource dc=0.0
Vg949 (c949 0) vsource dc=0.0
Vg950 (c950 0) vsource dc=0.0
Vg951 (c951 0) vsource dc=0.0
Vg952 (c952 0) vsource dc=0.0
Vg953 (c953 0) vsource dc=0.0
Vg954 (c954 0) vsource dc=0.0
Vg955 (c955 0) vsource dc=0.0
Vg956 (c956 0) vsource dc=0.0
Vg957 (c957 0) vsource dc=0.0
Vg958 (c958 0) vsource dc=0.0
Vg959 (c959 0) vsource dc=0.0
Vg960 (c960 0) vsource dc=0.0
Vg961 (c961 0) vsource dc=0.0
Vg962 (c962 0) vsource dc=0.0
Vg963 (c963 0) vsource dc=0.0
Vg964 (c964 0) vsource dc=0.0
Vg965 (c965 0) vsource dc=0.0
Vg966 (c966 0) vsource dc=0.0
Vg967 (c967 0) vsource dc=0.0
Vg968 (c968 0) vsource dc=0.0
Vg969 (c969 0) vsource dc=0.0
Vg970 (c970 0) vsource dc=0.0
Vg971 (c971 0) vsource dc=0.0
Vg972 (c972 0) vsource dc=0.0
Vg973 (c973 0) vsource dc=0.0
Vg974 (c974 0) vsource dc=0.0
Vg975 (c975 0) vsource dc=0.0
Vg976 (c976 0) vsource dc=0.0
Vg977 (c977 0) vsource dc=0.0
Vg978 (c978 0) vsource dc=0.0
Vg979 (c979 0) vsource dc=0.0
Vg980 (c980 0) vsource dc=0.0
Vg981 (c981 0) vsource dc=0.0
Vg982 (c982 0) vsource dc=0.0
Vg983 (c983 0) vsource dc=0.0
Vg984 (c984 0) vsource dc=0.0
Vg985 (c985 0) vsource dc=0.0
Vg986 (c986 0) vsource dc=0.0
Vg987 (c987 0) vsource dc=0.0
Vg988 (c988 0) vsource dc=0.0
Vg989 (c989 0) vsource dc=0.0
Vg990 (c990 0) vsource dc=0.0
Vg991 (c991 0) vsource dc=0.0
Vg992 (c992 0) vsource dc=0.0
Vg993 (c993 0) vsource dc=0.0
Vg994 (c994 0) vsource dc=0.0
Vg995 (c995 0) vsource dc=0.0
Vg996 (c996 0) vsource dc=0.0
Vg997 (c997 0) vsource dc=0.0
Vg998 (c998 0) vsource dc=0.0
Vg999 (c999 0) vsource dc=0.0
Vg1000 (c1000 0) vsource dc=0.0
Vg1001 (c1001 0) vsource dc=0.0
Vg1002 (c1002 0) vsource dc=0.0
Vg1003 (c1003 0) vsource dc=0.0
Vg1004 (c1004 0) vsource dc=0.0
Vg1005 (c1005 0) vsource dc=0.0
Vg1006 (c1006 0) vsource dc=0.0
Vg1007 (c1007 0) vsource dc=0.0
Vg1008 (c1008 0) vsource dc=0.0
Vg1009 (c1009 0) vsource dc=0.0
Vg1010 (c1010 0) vsource dc=0.0
Vg1011 (c1011 0) vsource dc=0.0
Vg1012 (c1012 0) vsource dc=0.0
Vg1013 (c1013 0) vsource dc=0.0
Vg1014 (c1014 0) vsource dc=0.0
Vg1015 (c1015 0) vsource dc=0.0
Vg1016 (c1016 0) vsource dc=0.0
Vg1017 (c1017 0) vsource dc=0.0
Vg1018 (c1018 0) vsource dc=0.0
Vg1019 (c1019 0) vsource dc=0.0
Vg1020 (c1020 0) vsource dc=0.0
Vg1021 (c1021 0) vsource dc=0.0
Vg1022 (c1022 0) vsource dc=0.0
Xdtc (CKIN CKOUT VDD VSS c0 c1 c2 c3 c4 c5 c6 c7 c8 c9 c10 c11 c12 c13 c14 c15 c16 c17 c18 c19 c20 c21 c22 c23 c24 c25 c26 c27 c28 c29 c30 c31 c32 c33 c34 c35 c36 c37 c38 c39 c40 c41 c42 c43 c44 c45 c46 c47 c48 c49 c50 c51 c52 c53 c54 c55 c56 c57 c58 c59 c60 c61 c62 c63 c64 c65 c66 c67 c68 c69 c70 c71 c72 c73 c74 c75 c76 c77 c78 c79 c80 c81 c82 c83 c84 c85 c86 c87 c88 c89 c90 c91 c92 c93 c94 c95 c96 c97 c98 c99 c100 c101 c102 c103 c104 c105 c106 c107 c108 c109 c110 c111 c112 c113 c114 c115 c116 c117 c118 c119 c120 c121 c122 c123 c124 c125 c126 c127 c128 c129 c130 c131 c132 c133 c134 c135 c136 c137 c138 c139 c140 c141 c142 c143 c144 c145 c146 c147 c148 c149 c150 c151 c152 c153 c154 c155 c156 c157 c158 c159 c160 c161 c162 c163 c164 c165 c166 c167 c168 c169 c170 c171 c172 c173 c174 c175 c176 c177 c178 c179 c180 c181 c182 c183 c184 c185 c186 c187 c188 c189 c190 c191 c192 c193 c194 c195 c196 c197 c198 c199 c200 c201 c202 c203 c204 c205 c206 c207 c208 c209 c210 c211 c212 c213 c214 c215 c216 c217 c218 c219 c220 c221 c222 c223 c224 c225 c226 c227 c228 c229 c230 c231 c232 c233 c234 c235 c236 c237 c238 c239 c240 c241 c242 c243 c244 c245 c246 c247 c248 c249 c250 c251 c252 c253 c254 c255 c256 c257 c258 c259 c260 c261 c262 c263 c264 c265 c266 c267 c268 c269 c270 c271 c272 c273 c274 c275 c276 c277 c278 c279 c280 c281 c282 c283 c284 c285 c286 c287 c288 c289 c290 c291 c292 c293 c294 c295 c296 c297 c298 c299 c300 c301 c302 c303 c304 c305 c306 c307 c308 c309 c310 c311 c312 c313 c314 c315 c316 c317 c318 c319 c320 c321 c322 c323 c324 c325 c326 c327 c328 c329 c330 c331 c332 c333 c334 c335 c336 c337 c338 c339 c340 c341 c342 c343 c344 c345 c346 c347 c348 c349 c350 c351 c352 c353 c354 c355 c356 c357 c358 c359 c360 c361 c362 c363 c364 c365 c366 c367 c368 c369 c370 c371 c372 c373 c374 c375 c376 c377 c378 c379 c380 c381 c382 c383 c384 c385 c386 c387 c388 c389 c390 c391 c392 c393 c394 c395 c396 c397 c398 c399 c400 c401 c402 c403 c404 c405 c406 c407 c408 c409 c410 c411 c412 c413 c414 c415 c416 c417 c418 c419 c420 c421 c422 c423 c424 c425 c426 c427 c428 c429 c430 c431 c432 c433 c434 c435 c436 c437 c438 c439 c440 c441 c442 c443 c444 c445 c446 c447 c448 c449 c450 c451 c452 c453 c454 c455 c456 c457 c458 c459 c460 c461 c462 c463 c464 c465 c466 c467 c468 c469 c470 c471 c472 c473 c474 c475 c476 c477 c478 c479 c480 c481 c482 c483 c484 c485 c486 c487 c488 c489 c490 c491 c492 c493 c494 c495 c496 c497 c498 c499 c500 c501 c502 c503 c504 c505 c506 c507 c508 c509 c510 c511 c512 c513 c514 c515 c516 c517 c518 c519 c520 c521 c522 c523 c524 c525 c526 c527 c528 c529 c530 c531 c532 c533 c534 c535 c536 c537 c538 c539 c540 c541 c542 c543 c544 c545 c546 c547 c548 c549 c550 c551 c552 c553 c554 c555 c556 c557 c558 c559 c560 c561 c562 c563 c564 c565 c566 c567 c568 c569 c570 c571 c572 c573 c574 c575 c576 c577 c578 c579 c580 c581 c582 c583 c584 c585 c586 c587 c588 c589 c590 c591 c592 c593 c594 c595 c596 c597 c598 c599 c600 c601 c602 c603 c604 c605 c606 c607 c608 c609 c610 c611 c612 c613 c614 c615 c616 c617 c618 c619 c620 c621 c622 c623 c624 c625 c626 c627 c628 c629 c630 c631 c632 c633 c634 c635 c636 c637 c638 c639 c640 c641 c642 c643 c644 c645 c646 c647 c648 c649 c650 c651 c652 c653 c654 c655 c656 c657 c658 c659 c660 c661 c662 c663 c664 c665 c666 c667 c668 c669 c670 c671 c672 c673 c674 c675 c676 c677 c678 c679 c680 c681 c682 c683 c684 c685 c686 c687 c688 c689 c690 c691 c692 c693 c694 c695 c696 c697 c698 c699 c700 c701 c702 c703 c704 c705 c706 c707 c708 c709 c710 c711 c712 c713 c714 c715 c716 c717 c718 c719 c720 c721 c722 c723 c724 c725 c726 c727 c728 c729 c730 c731 c732 c733 c734 c735 c736 c737 c738 c739 c740 c741 c742 c743 c744 c745 c746 c747 c748 c749 c750 c751 c752 c753 c754 c755 c756 c757 c758 c759 c760 c761 c762 c763 c764 c765 c766 c767 c768 c769 c770 c771 c772 c773 c774 c775 c776 c777 c778 c779 c780 c781 c782 c783 c784 c785 c786 c787 c788 c789 c790 c791 c792 c793 c794 c795 c796 c797 c798 c799 c800 c801 c802 c803 c804 c805 c806 c807 c808 c809 c810 c811 c812 c813 c814 c815 c816 c817 c818 c819 c820 c821 c822 c823 c824 c825 c826 c827 c828 c829 c830 c831 c832 c833 c834 c835 c836 c837 c838 c839 c840 c841 c842 c843 c844 c845 c846 c847 c848 c849 c850 c851 c852 c853 c854 c855 c856 c857 c858 c859 c860 c861 c862 c863 c864 c865 c866 c867 c868 c869 c870 c871 c872 c873 c874 c875 c876 c877 c878 c879 c880 c881 c882 c883 c884 c885 c886 c887 c888 c889 c890 c891 c892 c893 c894 c895 c896 c897 c898 c899 c900 c901 c902 c903 c904 c905 c906 c907 c908 c909 c910 c911 c912 c913 c914 c915 c916 c917 c918 c919 c920 c921 c922 c923 c924 c925 c926 c927 c928 c929 c930 c931 c932 c933 c934 c935 c936 c937 c938 c939 c940 c941 c942 c943 c944 c945 c946 c947 c948 c949 c950 c951 c952 c953 c954 c955 c956 c957 c958 c959 c960 c961 c962 c963 c964 c965 c966 c967 c968 c969 c970 c971 c972 c973 c974 c975 c976 c977 c978 c979 c980 c981 c982 c983 c984 c985 c986 c987 c988 c989 c990 c991 c992 c993 c994 c995 c996 c997 c998 c999 c1000 c1001 c1002 c1003 c1004 c1005 c1006 c1007 c1008 c1009 c1010 c1011 c1012 c1013 c1014 c1015 c1016 c1017 c1018 c1019 c1020 c1021 c1022) dtc_10b
Rload (CKOUT 0) resistor r=1e6

plltran tran stop=40n maxstep=2p errpreset=liberal method=gear2only skipdc=yes
save CKIN CKOUT
