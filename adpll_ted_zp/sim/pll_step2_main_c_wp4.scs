// pll_step2_main_c.scs — Plan C (paper-faithful) top-level
// fref=100M, fvco=8G integer channel; 0.5V VCO core from on-chip LDO,
// split control: VCTRL_P (VHOLD, proportional VAR_P) / VCTRL_I (VI, VAR_I)
// Generated by hand from pll_step2_main.scs; Plan C deltas marked [C]
simulator lang=spectre

include "/home/lib/tsmc_12nm_installed/pdk/models/toplevel.scs" section=top_tt
include "dtc_10b.scs"
include "vco_c.scs"
include "ldo_05.scs"
include "spd_cmp_gm.scs"
ahdl_include "pll_mmd_edge.va"
ahdl_include "pll_lms.va"
ahdl_include "pll_dtc_decoder_10b.va"
ahdl_include "pll_hybrid_aux.va"

Vvdd (VDD 0) vsource dc=0.8
Vvss (VSS 0) vsource dc=0
Vref (REF 0) vsource type=pulse val0=0 val1=0.8 period=1.000000e-08 width=5.000000e-09 rise=10p fall=10p
Vbspd (VBSPD 0) vsource dc=0.52
Vbcmp (VBCMP 0) vsource dc=0.8
Vbgm  (VBGM 0) vsource dc=0.8

// [C] 1V supply for the LDO input + bandgap ref (ideal v1) + EA tail bias
Vv1v (V1V 0) vsource dc=1.0
Vvbg (VBG 0) vsource dc=0.5
Vvbl (VBL 0) vsource dc=0.62

// [C] LDO: 1.0V -> 0.5V VCO core supply
Xldo (VDD V1V VBG VBL VDDC VSS) ldo_05

// [C] enable codes: all banks on (EN=0); VAR_I full ~440MHz/V (v2 direct
//     moscap: units nfin 2/2/4, ENI0 unit measured 110MHz/V), VAR_P 5-bit
Veni0 (ENI0 0) vsource dc=0
Veni1 (ENI1 0) vsource dc=0
Veni2 (ENI2 0) vsource dc=0
Venp0 (ENP0 0) vsource dc=0
Venp1 (ENP1 0) vsource dc=0
Venp2 (ENP2 0) vsource dc=0.8
Venp3 (ENP3 0) vsource dc=0.8
Venp4 (ENP4 0) vsource dc=0.8

Venv2 (EN2 0) vsource dc=0.8
Xvco (VDD VDDC VSS VCTRL_P VCTRL_I OUTP OUTN EN2 \
    ENI0 ENI1 ENI2 ENP0 ENP1 ENP2 ENP3 ENP4) vco_dual_8g_c
// plan A': decoder moved INSIDE dtc_10b (paper architecture); only 11 external ports
Xdtc (CK2X CKDTCD VDD VSS CKFB KDTC EPSC SEL ALT VDCC RDCC) dtc_10b
Xspd (VBSPD CKRST CKFB VHOLD VRAMP VDD VSS) spd_x
Xcmp (VHOLD VREF VBCMP EBIT VDD VSS) cmp_x
Xgm  (VHOLD VREF VBGM VI VDD VSS) gm_x

Edbl (CK2X 0 REF 0) vcvs gain=1.0  // step2: 100M 参考不经倍频
Einv (CKRSTI 0 CKDTCD 0) vcvs gain=-1.0
Vrstofs (VDC08 0) vsource dc=0.8
Esumrst (CKRST VDC08 CKRSTI 0) vcvs gain=1.0

Minvbuf_n (NBUF1 BUFFIN VSS VSS) nch_svt_mac l=16n nfin=2 w=58n multi=1 nf=4 sd=74n sa=90n sb=90n ploda1=16n ploda2=0 ploda3=0 plodb1=16n plodb2=0 plodb3=0 nf_flag=1 smbt=1M smbb=1M dinsaflag=0 ppitch=0 spot=103n spob=103n spotl1=103n spobl1=103n spotl2=103n spobl2=103n spotr1=103n spobr1=103n spotr2=103n spobr2=103n
Minvbuf_p (NBUF1 BUFFIN VDD VDD) pch_svt_mac l=16n nfin=2 w=58n multi=1 nf=4 sd=74n sa=90n sb=90n ploda1=16n ploda2=0 ploda3=0 plodb1=16n plodb2=0 plodb3=0 nf_flag=1 smbt=1M smbb=1M dinsaflag=0 ppitch=0 spot=103n spob=103n spotl1=103n spobl1=103n spotl2=103n spobl2=103n spotr1=103n spobr1=103n spotr2=103n spobr2=103n
Minvbuf2_n (MMDIN NBUF1 VSS VSS) nch_svt_mac l=16n nfin=2 w=58n multi=1 nf=4 sd=74n sa=90n sb=90n ploda1=16n ploda2=0 ploda3=0 plodb1=16n plodb2=0 plodb3=0 nf_flag=1 smbt=1M smbb=1M dinsaflag=0 ppitch=0 spot=103n spob=103n spotl1=103n spobl1=103n spotl2=103n spobl2=103n spotr1=103n spobr1=103n spotr2=103n spobr2=103n
Minvbuf2_p (MMDIN NBUF1 VDD VDD) pch_svt_mac l=16n nfin=2 w=58n multi=1 nf=4 sd=74n sa=90n sb=90n ploda1=16n ploda2=0 ploda3=0 plodb1=16n plodb2=0 plodb3=0 nf_flag=1 smbt=1M smbb=1M dinsaflag=0 ppitch=0 spot=103n spob=103n spotl1=103n spobl1=103n spotl2=103n spobl2=103n spotr1=103n spobr1=103n spotr2=103n spobr2=103n
Rbuf (OUTP BUFFIN) resistor r=1k

Xmmd (MMDIN CKFB SEL ALT EPSC ERR) pll_mmd_edge Nint2=80.0 frac2=0.0 vth=0.7
Xclkl (CKFB CLKLMS) pll_clk_lms vth=0.4
Xlms (CLKLMS EBIT SEL ALT EPSC KDTC VDCC RDCC VREF) pll_lms \
    mu_k=0.0 mu_v=0.0 mu_r=1e-13 mu_off=4.2e-13 K0=1.0 vdcc0=12e-12 rdcc0=-12e-12 ohat0=32e-12 \
    offset_s=32e-12 vref0=0.45 fref=1.000000e+08 m_slope=1e9 mode=1 tscale=1e-6 seed=121

Xci (VI 0) capacitor c=2p ic=0.30
// [C] 预充电: 0-2ns 注入 300uA -> VI≈0.30V (0.5V-core moscap 过渡区新工作点,
//     实测 KVCO 单调区 VCTRL_I ∈ [0.15, 0.5], 从近锁定状态启动)
Iinj (VI 0) isource type=pulse val0=0 val1=-300u delay=0 width=2n period=1m rise=10p fall=10p

// [C] VCTRL_I = VI (same node: GM integral output drives VAR_I bulk)
Cic_Xa_VI00p (Xvco.Xa.VI00p_cb 0) capacitor c=1f ic=0.4
Cic_Xa_VI00n (Xvco.Xa.VI00n_cb 0) capacitor c=1f ic=0.4
Cic_Xa_VI10p (Xvco.Xa.VI10p_cb 0) capacitor c=1f ic=0.4
Cic_Xa_VI10n (Xvco.Xa.VI10n_cb 0) capacitor c=1f ic=0.4
Cic_Xa_VI20p (Xvco.Xa.VI20p_cb 0) capacitor c=1f ic=0.4
Cic_Xa_VI20n (Xvco.Xa.VI20n_cb 0) capacitor c=1f ic=0.4
Cic_Xa_VP00p (Xvco.Xa.VP00p_cb 0) capacitor c=1f ic=0.5
Cic_Xa_VP00n (Xvco.Xa.VP00n_cb 0) capacitor c=1f ic=0.5
Cic_Xa_VP10p (Xvco.Xa.VP10p_cb 0) capacitor c=1f ic=0.5
Cic_Xa_VP10n (Xvco.Xa.VP10n_cb 0) capacitor c=1f ic=0.5
Cic_Xa_VP11p (Xvco.Xa.VP11p_cb 0) capacitor c=1f ic=0.5
Cic_Xa_VP11n (Xvco.Xa.VP11n_cb 0) capacitor c=1f ic=0.5
Cic_Xb_VI00p (Xvco.Xb.VI00p_cb 0) capacitor c=1f ic=0.4
Cic_Xb_VI00n (Xvco.Xb.VI00n_cb 0) capacitor c=1f ic=0.4
Cic_Xb_VI10p (Xvco.Xb.VI10p_cb 0) capacitor c=1f ic=0.4
Cic_Xb_VI10n (Xvco.Xb.VI10n_cb 0) capacitor c=1f ic=0.4
Cic_Xb_VI20p (Xvco.Xb.VI20p_cb 0) capacitor c=1f ic=0.4
Cic_Xb_VI20n (Xvco.Xb.VI20n_cb 0) capacitor c=1f ic=0.4
Cic_Xb_VP00p (Xvco.Xb.VP00p_cb 0) capacitor c=1f ic=0.5
Cic_Xb_VP00n (Xvco.Xb.VP00n_cb 0) capacitor c=1f ic=0.5
Cic_Xb_VP10p (Xvco.Xb.VP10p_cb 0) capacitor c=1f ic=0.5
Cic_Xb_VP10n (Xvco.Xb.VP10n_cb 0) capacitor c=1f ic=0.5
Cic_Xb_VP11p (Xvco.Xb.VP11p_cb 0) capacitor c=1f ic=0.5
Cic_Xb_VP11n (Xvco.Xb.VP11n_cb 0) capacitor c=1f ic=0.5
// [C] VCTRL_P = VHOLD through ideal unity buffer (v1 placeholder;
//     real source-follower buffer pending VHOLD hold-cap droop check)
Ebufp (VCTRL_P 0 VHOLD 0) vcvs gain=1.0

plltran tran stop=300n maxstep=2p errpreset=liberal method=gear2only skipdc=yes ic="OUTP=0.45" ic="Xvco.Xa.VI00p_cb=0.4" ic="Xvco.Xa.VI00n_cb=0.4" ic="Xvco.Xa.VI10p_cb=0.4" ic="Xvco.Xa.VI10n_cb=0.4" ic="Xvco.Xa.VI20p_cb=0.4" ic="Xvco.Xa.VI20n_cb=0.4" ic="Xvco.Xa.VP00p_cb=0.5" ic="Xvco.Xa.VP00n_cb=0.5" ic="Xvco.Xa.VP10p_cb=0.5" ic="Xvco.Xa.VP10n_cb=0.5" ic="Xvco.Xa.VP11p_cb=0.5" ic="Xvco.Xa.VP11n_cb=0.5" ic="Xvco.Xb.VI00p_cb=0.4" ic="Xvco.Xb.VI00n_cb=0.4" ic="Xvco.Xb.VI10p_cb=0.4" ic="Xvco.Xb.VI10n_cb=0.4" ic="Xvco.Xb.VI20p_cb=0.4" ic="Xvco.Xb.VI20n_cb=0.4" ic="Xvco.Xb.VP00p_cb=0.5" ic="Xvco.Xb.VP00n_cb=0.5" ic="Xvco.Xb.VP10p_cb=0.5" ic="Xvco.Xb.VP10n_cb=0.5" ic="Xvco.Xb.VP11p_cb=0.5" ic="Xvco.Xb.VP11n_cb=0.5"
save OUTP CKFB VCTRL_P VCTRL_I VI VHOLD EBIT MMDIN NBUF1 VREF VDCC RDCC KDTC VRAMP SEL EPSC CK2X CKDTCD CKRST VDDC
saveOptions options save=selected
