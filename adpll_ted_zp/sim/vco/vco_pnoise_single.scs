// VCO 开环相噪标定 单核: 直接实例化 vco_x (无核心B)
simulator lang=spectre
include "/home/lib/tsmc_12nm_installed/pdk/models/toplevel.scs" section=top_tt
include "vco_dual.scs"

Vvdd (VDD 0) vsource dc=0.8
Vvss (VSS 0) vsource dc=0
Vctrl (VCTRL 0) vsource dc=0.5

Xvco (VDD VSS VCTRL OUTP OUTN) vco_x

pllpss (OUTP OUTN) pss fund=6.1G harms=10 errpreset=liberal tstab=60n maxstep=1p
pllpnoise (OUTP OUTN) pnoise start=10k stop=100M maxsideband=20 refsideband=0 \
    type=log points=200 op=1
