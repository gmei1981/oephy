// cmp_x 传输曲线标定: DC 扫 VINP, VREF=0.4, VBCMP=0.8 (基准与 tb 对照)
simulator lang=spectre
include "/home/lib/tsmc_12nm_installed/pdk/models/toplevel.scs" section=top_tt
include "spd_cmp_gm.scs"

Vvdd (VDD 0) vsource dc=0.8
Vvss (VSS 0) vsource dc=0
Vb (VBCMP 0) vsource dc=0.8
Vr (VREF 0) vsource dc=0.4
Vi (VINP 0) vsource dc=0.4
Xcmp (VINP VREF VBCMP EBIT VDD VSS) cmp_x
plldc dc dev=Vi param=dc start=0 stop=0.8 step=1m
save EBIT
