// adpll_sch/ldo_05/schematic
MTAIL (TAIL VBL VSS VSS) nch_ulvt_mac l=16n nfin=2 w=58n multi=1 nf=1 sd=74n sa=90n sb=90n ploda1=16n ploda2=0 ploda3=0 plodb1=16n plodb2=0 plodb3=0 nf_flag=1 smbt=1M smbb=1M dinsaflag=0 ppitch=0 spot=103n spob=103n spotl1=103n spobl1=103n spotl2=103n spobl2=103n spotr1=103n spobr1=103n spotr2=103n spobr2=103n
MN2 (VDP VBG TAIL VSS) nch_ulvt_mac l=16n nfin=2 w=58n multi=1 nf=4 sd=74n sa=90n sb=90n ploda1=16n ploda2=0 ploda3=0 plodb1=16n plodb2=0 plodb3=0 nf_flag=1 smbt=1M smbb=1M dinsaflag=0 ppitch=0 spot=103n spob=103n spotl1=103n spobl1=103n spotl2=103n spobl2=103n spotr1=103n spobr1=103n spotr2=103n spobr2=103n
MN1 (VDN VOUT TAIL VSS) nch_ulvt_mac l=16n nfin=2 w=58n multi=1 nf=4 sd=74n sa=90n sb=90n ploda1=16n ploda2=0 ploda3=0 plodb1=16n plodb2=0 plodb3=0 nf_flag=1 smbt=1M smbb=1M dinsaflag=0 ppitch=0 spot=103n spob=103n spotl1=103n spobl1=103n spotl2=103n spobl2=103n spotr1=103n spobr1=103n spotr2=103n spobr2=103n
MPASS (VOUT VGATE VIN VIN) pch_svt_mac l=16n nfin=2 w=58n multi=1 nf=256 sd=74n sa=90n sb=90n ploda1=16n ploda2=0 ploda3=0 plodb1=16n plodb2=0 plodb3=0 nf_flag=1 smbt=1M smbb=1M dinsaflag=0 ppitch=0 spot=103n spob=103n spotl1=103n spobl1=103n spotl2=103n spobl2=103n spotr1=103n spobr1=103n spotr2=103n spobr2=103n
MP2 (VDP VDN VDD VDD) pch_svt_mac l=16n nfin=2 w=58n multi=1 nf=2 sd=74n sa=90n sb=90n ploda1=16n ploda2=0 ploda3=0 plodb1=16n plodb2=0 plodb3=0 nf_flag=1 smbt=1M smbb=1M dinsaflag=0 ppitch=0 spot=103n spob=103n spotl1=103n spobl1=103n spotl2=103n spobl2=103n spotr1=103n spobr1=103n spotr2=103n spobr2=103n
MP1 (VDN VDN VDD VDD) pch_svt_mac l=16n nfin=2 w=58n multi=1 nf=2 sd=74n sa=90n sb=90n ploda1=16n ploda2=0 ploda3=0 plodb1=16n plodb2=0 plodb3=0 nf_flag=1 smbt=1M smbb=1M dinsaflag=0 ppitch=0 spot=103n spob=103n spotl1=103n spobl1=103n spotl2=103n spobl2=103n spotr1=103n spobr1=103n spotr2=103n spobr2=103n
RLPF (VDP VGATE) resistor r=2k
COUT (VOUT VSS) capacitor c=20p
CLPF (VGATE VSS) capacitor c=2p
