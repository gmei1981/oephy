;; auto-generated schematic drawing script for cmp_x
;
(let ((cv nil) (inst nil) (ip nil) (trm nil) (a1 nil) (a2 nil) (anch nil) (xm 0.0))
  (unless (ddGetObj "adpll_sch") (dbCreateLib "adpll_sch"))
  (setq cv (dbOpenCellViewByType "adpll_sch" "cmp_x" "schematic" "schematic" "a"))
  ;; ---- instances ----
  (setq ih (makeTable 'ih nil))
  (setq inst (dbCreateInstByMasterName cv "tsmcN12" "pch_svt_mac" "symbol" "MP2" 0:0 "R0"))
  (setarray ih "MP2" inst)
  (dbReplaceProp inst "l" "float" 1.6e-08)
  (dbReplaceProp inst "nfin" "float" 2)
  (dbReplaceProp inst "w" "float" 5.8e-08)
  (dbReplaceProp inst "multi" "float" 1)
  (dbReplaceProp inst "nf" "float" 2)
  (dbReplaceProp inst "sd" "float" 7.4e-08)
  (dbReplaceProp inst "sa" "float" 9e-08)
  (dbReplaceProp inst "sb" "float" 9e-08)
  (dbReplaceProp inst "ploda1" "float" 1.6e-08)
  (dbReplaceProp inst "ploda2" "float" 0)
  (dbReplaceProp inst "ploda3" "float" 0)
  (dbReplaceProp inst "plodb1" "float" 1.6e-08)
  (dbReplaceProp inst "plodb2" "float" 0)
  (dbReplaceProp inst "plodb3" "float" 0)
  (dbReplaceProp inst "nf_flag" "float" 1)
  (dbReplaceProp inst "smbt" "float" 1000000)
  (dbReplaceProp inst "smbb" "float" 1000000)
  (dbReplaceProp inst "dinsaflag" "float" 0)
  (dbReplaceProp inst "ppitch" "float" 0)
  (dbReplaceProp inst "spot" "float" 1.03e-07)
  (dbReplaceProp inst "spob" "float" 1.03e-07)
  (dbReplaceProp inst "spotl1" "float" 1.03e-07)
  (dbReplaceProp inst "spobl1" "float" 1.03e-07)
  (dbReplaceProp inst "spotl2" "float" 1.03e-07)
  (dbReplaceProp inst "spobl2" "float" 1.03e-07)
  (dbReplaceProp inst "spotr1" "float" 1.03e-07)
  (dbReplaceProp inst "spobr1" "float" 1.03e-07)
  (dbReplaceProp inst "spotr2" "float" 1.03e-07)
  (dbReplaceProp inst "spobr2" "float" 1.03e-07)
  (setq inst (dbCreateInstByMasterName cv "tsmcN12" "nch_svt_mac" "symbol" "MN2" 0:-4 "R0"))
  (setarray ih "MN2" inst)
  (dbReplaceProp inst "l" "float" 1.6e-08)
  (dbReplaceProp inst "nfin" "float" 2)
  (dbReplaceProp inst "w" "float" 5.8e-08)
  (dbReplaceProp inst "multi" "float" 1)
  (dbReplaceProp inst "nf" "float" 2)
  (dbReplaceProp inst "sd" "float" 7.4e-08)
  (dbReplaceProp inst "sa" "float" 9e-08)
  (dbReplaceProp inst "sb" "float" 9e-08)
  (dbReplaceProp inst "ploda1" "float" 1.6e-08)
  (dbReplaceProp inst "ploda2" "float" 0)
  (dbReplaceProp inst "ploda3" "float" 0)
  (dbReplaceProp inst "plodb1" "float" 1.6e-08)
  (dbReplaceProp inst "plodb2" "float" 0)
  (dbReplaceProp inst "plodb3" "float" 0)
  (dbReplaceProp inst "nf_flag" "float" 1)
  (dbReplaceProp inst "smbt" "float" 1000000)
  (dbReplaceProp inst "smbb" "float" 1000000)
  (dbReplaceProp inst "dinsaflag" "float" 0)
  (dbReplaceProp inst "ppitch" "float" 0)
  (dbReplaceProp inst "spot" "float" 1.03e-07)
  (dbReplaceProp inst "spob" "float" 1.03e-07)
  (dbReplaceProp inst "spotl1" "float" 1.03e-07)
  (dbReplaceProp inst "spobl1" "float" 1.03e-07)
  (dbReplaceProp inst "spotl2" "float" 1.03e-07)
  (dbReplaceProp inst "spobl2" "float" 1.03e-07)
  (dbReplaceProp inst "spotr1" "float" 1.03e-07)
  (dbReplaceProp inst "spobr1" "float" 1.03e-07)
  (dbReplaceProp inst "spotr2" "float" 1.03e-07)
  (dbReplaceProp inst "spobr2" "float" 1.03e-07)
  (setq inst (dbCreateInstByMasterName cv "tsmcN12" "pch_svt_mac" "symbol" "MP1" 4:0 "R0"))
  (setarray ih "MP1" inst)
  (dbReplaceProp inst "l" "float" 1.6e-08)
  (dbReplaceProp inst "nfin" "float" 2)
  (dbReplaceProp inst "w" "float" 5.8e-08)
  (dbReplaceProp inst "multi" "float" 1)
  (dbReplaceProp inst "nf" "float" 2)
  (dbReplaceProp inst "sd" "float" 7.4e-08)
  (dbReplaceProp inst "sa" "float" 9e-08)
  (dbReplaceProp inst "sb" "float" 9e-08)
  (dbReplaceProp inst "ploda1" "float" 1.6e-08)
  (dbReplaceProp inst "ploda2" "float" 0)
  (dbReplaceProp inst "ploda3" "float" 0)
  (dbReplaceProp inst "plodb1" "float" 1.6e-08)
  (dbReplaceProp inst "plodb2" "float" 0)
  (dbReplaceProp inst "plodb3" "float" 0)
  (dbReplaceProp inst "nf_flag" "float" 1)
  (dbReplaceProp inst "smbt" "float" 1000000)
  (dbReplaceProp inst "smbb" "float" 1000000)
  (dbReplaceProp inst "dinsaflag" "float" 0)
  (dbReplaceProp inst "ppitch" "float" 0)
  (dbReplaceProp inst "spot" "float" 1.03e-07)
  (dbReplaceProp inst "spob" "float" 1.03e-07)
  (dbReplaceProp inst "spotl1" "float" 1.03e-07)
  (dbReplaceProp inst "spobl1" "float" 1.03e-07)
  (dbReplaceProp inst "spotl2" "float" 1.03e-07)
  (dbReplaceProp inst "spobl2" "float" 1.03e-07)
  (dbReplaceProp inst "spotr1" "float" 1.03e-07)
  (dbReplaceProp inst "spobr1" "float" 1.03e-07)
  (dbReplaceProp inst "spotr2" "float" 1.03e-07)
  (dbReplaceProp inst "spobr2" "float" 1.03e-07)
  (setq inst (dbCreateInstByMasterName cv "tsmcN12" "nch_svt_mac" "symbol" "MN1" 4:-4 "R0"))
  (setarray ih "MN1" inst)
  (dbReplaceProp inst "l" "float" 1.6e-08)
  (dbReplaceProp inst "nfin" "float" 2)
  (dbReplaceProp inst "w" "float" 5.8e-08)
  (dbReplaceProp inst "multi" "float" 1)
  (dbReplaceProp inst "nf" "float" 2)
  (dbReplaceProp inst "sd" "float" 7.4e-08)
  (dbReplaceProp inst "sa" "float" 9e-08)
  (dbReplaceProp inst "sb" "float" 9e-08)
  (dbReplaceProp inst "ploda1" "float" 1.6e-08)
  (dbReplaceProp inst "ploda2" "float" 0)
  (dbReplaceProp inst "ploda3" "float" 0)
  (dbReplaceProp inst "plodb1" "float" 1.6e-08)
  (dbReplaceProp inst "plodb2" "float" 0)
  (dbReplaceProp inst "plodb3" "float" 0)
  (dbReplaceProp inst "nf_flag" "float" 1)
  (dbReplaceProp inst "smbt" "float" 1000000)
  (dbReplaceProp inst "smbb" "float" 1000000)
  (dbReplaceProp inst "dinsaflag" "float" 0)
  (dbReplaceProp inst "ppitch" "float" 0)
  (dbReplaceProp inst "spot" "float" 1.03e-07)
  (dbReplaceProp inst "spob" "float" 1.03e-07)
  (dbReplaceProp inst "spotl1" "float" 1.03e-07)
  (dbReplaceProp inst "spobl1" "float" 1.03e-07)
  (dbReplaceProp inst "spotl2" "float" 1.03e-07)
  (dbReplaceProp inst "spobl2" "float" 1.03e-07)
  (dbReplaceProp inst "spotr1" "float" 1.03e-07)
  (dbReplaceProp inst "spobr1" "float" 1.03e-07)
  (dbReplaceProp inst "spotr2" "float" 1.03e-07)
  (dbReplaceProp inst "spobr2" "float" 1.03e-07)
  (setq inst (dbCreateInstByMasterName cv "tsmcN12" "nch_svt_mac" "symbol" "MTAIL" 8:-4 "R0"))
  (setarray ih "MTAIL" inst)
  (dbReplaceProp inst "l" "float" 1.6e-08)
  (dbReplaceProp inst "nfin" "float" 2)
  (dbReplaceProp inst "w" "float" 5.8e-08)
  (dbReplaceProp inst "multi" "float" 1)
  (dbReplaceProp inst "nf" "float" 2)
  (dbReplaceProp inst "sd" "float" 7.4e-08)
  (dbReplaceProp inst "sa" "float" 9e-08)
  (dbReplaceProp inst "sb" "float" 9e-08)
  (dbReplaceProp inst "ploda1" "float" 1.6e-08)
  (dbReplaceProp inst "ploda2" "float" 0)
  (dbReplaceProp inst "ploda3" "float" 0)
  (dbReplaceProp inst "plodb1" "float" 1.6e-08)
  (dbReplaceProp inst "plodb2" "float" 0)
  (dbReplaceProp inst "plodb3" "float" 0)
  (dbReplaceProp inst "nf_flag" "float" 1)
  (dbReplaceProp inst "smbt" "float" 1000000)
  (dbReplaceProp inst "smbb" "float" 1000000)
  (dbReplaceProp inst "dinsaflag" "float" 0)
  (dbReplaceProp inst "ppitch" "float" 0)
  (dbReplaceProp inst "spot" "float" 1.03e-07)
  (dbReplaceProp inst "spob" "float" 1.03e-07)
  (dbReplaceProp inst "spotl1" "float" 1.03e-07)
  (dbReplaceProp inst "spobl1" "float" 1.03e-07)
  (dbReplaceProp inst "spotl2" "float" 1.03e-07)
  (dbReplaceProp inst "spobl2" "float" 1.03e-07)
  (dbReplaceProp inst "spotr1" "float" 1.03e-07)
  (dbReplaceProp inst "spobr1" "float" 1.03e-07)
  (dbReplaceProp inst "spotr2" "float" 1.03e-07)
  (dbReplaceProp inst "spobr2" "float" 1.03e-07)
  (setq inst (dbCreateInstByMasterName cv "tsmcN12" "pch_svt_mac" "symbol" "MP3" 12:0 "R0"))
  (setarray ih "MP3" inst)
  (dbReplaceProp inst "l" "float" 1.6e-08)
  (dbReplaceProp inst "nfin" "float" 2)
  (dbReplaceProp inst "w" "float" 5.8e-08)
  (dbReplaceProp inst "multi" "float" 1)
  (dbReplaceProp inst "nf" "float" 2)
  (dbReplaceProp inst "sd" "float" 7.4e-08)
  (dbReplaceProp inst "sa" "float" 9e-08)
  (dbReplaceProp inst "sb" "float" 9e-08)
  (dbReplaceProp inst "ploda1" "float" 1.6e-08)
  (dbReplaceProp inst "ploda2" "float" 0)
  (dbReplaceProp inst "ploda3" "float" 0)
  (dbReplaceProp inst "plodb1" "float" 1.6e-08)
  (dbReplaceProp inst "plodb2" "float" 0)
  (dbReplaceProp inst "plodb3" "float" 0)
  (dbReplaceProp inst "nf_flag" "float" 1)
  (dbReplaceProp inst "smbt" "float" 1000000)
  (dbReplaceProp inst "smbb" "float" 1000000)
  (dbReplaceProp inst "dinsaflag" "float" 0)
  (dbReplaceProp inst "ppitch" "float" 0)
  (dbReplaceProp inst "spot" "float" 1.03e-07)
  (dbReplaceProp inst "spob" "float" 1.03e-07)
  (dbReplaceProp inst "spotl1" "float" 1.03e-07)
  (dbReplaceProp inst "spobl1" "float" 1.03e-07)
  (dbReplaceProp inst "spotl2" "float" 1.03e-07)
  (dbReplaceProp inst "spobl2" "float" 1.03e-07)
  (dbReplaceProp inst "spotr1" "float" 1.03e-07)
  (dbReplaceProp inst "spobr1" "float" 1.03e-07)
  (dbReplaceProp inst "spotr2" "float" 1.03e-07)
  (dbReplaceProp inst "spobr2" "float" 1.03e-07)
  (setq inst (dbCreateInstByMasterName cv "tsmcN12" "nch_svt_mac" "symbol" "MN3" 12:-4 "R0"))
  (setarray ih "MN3" inst)
  (dbReplaceProp inst "l" "float" 1.6e-08)
  (dbReplaceProp inst "nfin" "float" 2)
  (dbReplaceProp inst "w" "float" 5.8e-08)
  (dbReplaceProp inst "multi" "float" 1)
  (dbReplaceProp inst "nf" "float" 2)
  (dbReplaceProp inst "sd" "float" 7.4e-08)
  (dbReplaceProp inst "sa" "float" 9e-08)
  (dbReplaceProp inst "sb" "float" 9e-08)
  (dbReplaceProp inst "ploda1" "float" 1.6e-08)
  (dbReplaceProp inst "ploda2" "float" 0)
  (dbReplaceProp inst "ploda3" "float" 0)
  (dbReplaceProp inst "plodb1" "float" 1.6e-08)
  (dbReplaceProp inst "plodb2" "float" 0)
  (dbReplaceProp inst "plodb3" "float" 0)
  (dbReplaceProp inst "nf_flag" "float" 1)
  (dbReplaceProp inst "smbt" "float" 1000000)
  (dbReplaceProp inst "smbb" "float" 1000000)
  (dbReplaceProp inst "dinsaflag" "float" 0)
  (dbReplaceProp inst "ppitch" "float" 0)
  (dbReplaceProp inst "spot" "float" 1.03e-07)
  (dbReplaceProp inst "spob" "float" 1.03e-07)
  (dbReplaceProp inst "spotl1" "float" 1.03e-07)
  (dbReplaceProp inst "spobl1" "float" 1.03e-07)
  (dbReplaceProp inst "spotl2" "float" 1.03e-07)
  (dbReplaceProp inst "spobl2" "float" 1.03e-07)
  (dbReplaceProp inst "spotr1" "float" 1.03e-07)
  (dbReplaceProp inst "spobr1" "float" 1.03e-07)
  (dbReplaceProp inst "spotr2" "float" 1.03e-07)
  (dbReplaceProp inst "spobr2" "float" 1.03e-07)
  ;; (instances only: wiring/pins deferred to GUI or follow-up round)
  (dbSave cv)
  (geOpen ?lib "adpll_sch" ?cell "cmp_x" ?view "schematic" ?mode "r")
  (errset (hiExportImage (hiGetCurrentWindow) "/home/gmei/git/oephy/adpll_ted/virtuoso_ws/cmp_x.png"))
  (sleep 3600)
  )
