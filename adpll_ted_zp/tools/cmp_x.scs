subckt cmp_x (VINP VINN VBIAS EOUT VDD VSS)

MN3 (EOUT OUTP1 VSS VSS) nch_svt_mac l=16n nfin=2 w=58n multi=1 nf=2 \
        sd=74n sa=90n sb=90n ploda1=16n ploda2=0 ploda3=0 plodb1=16n \
        plodb2=0 plodb3=0 nf_flag=1 smbt=1M smbb=1M dinsaflag=0 ppitch=0 \
        spot=103n spob=103n spotl1=103n spobl1=103n spotl2=103n \
        spobl2=103n spotr1=103n spobr1=103n spotr2=103n spobr2=103n
MN2 (OUTP1 VINP TAILN VSS) nch_svt_mac l=16n nfin=2 w=58n multi=1 nf=2 \
        sd=74n sa=90n sb=90n ploda1=16n ploda2=0 ploda3=0 plodb1=16n \
        plodb2=0 plodb3=0 nf_flag=1 smbt=1M smbb=1M dinsaflag=0 ppitch=0 \
        spot=103n spob=103n spotl1=103n spobl1=103n spotl2=103n \
        spobl2=103n spotr1=103n spobr1=103n spotr2=103n spobr2=103n
MN1 (OUTN1 VINN TAILN VSS) nch_svt_mac l=16n nfin=2 w=58n multi=1 nf=2 \
        sd=74n sa=90n sb=90n ploda1=16n ploda2=0 ploda3=0 plodb1=16n \
        plodb2=0 plodb3=0 nf_flag=1 smbt=1M smbb=1M dinsaflag=0 ppitch=0 \
        spot=103n spob=103n spotl1=103n spobl1=103n spotl2=103n \
        spobl2=103n spotr1=103n spobr1=103n spotr2=103n spobr2=103n
MTAIL (TAILN VBIAS VSS VSS) nch_svt_mac l=16n nfin=2 w=58n multi=1 nf=2 \
        sd=74n sa=90n sb=90n ploda1=16n ploda2=0 ploda3=0 plodb1=16n \
        plodb2=0 plodb3=0 nf_flag=1 smbt=1M smbb=1M dinsaflag=0 ppitch=0 \
        spot=103n spob=103n spotl1=103n spobl1=103n spotl2=103n \
        spobl2=103n spotr1=103n spobr1=103n spotr2=103n spobr2=103n
MP3 (EOUT OUTP1 VDD VDD) pch_svt_mac l=16n nfin=2 w=58n multi=1 nf=2 \
        sd=74n sa=90n sb=90n ploda1=16n ploda2=0 ploda3=0 plodb1=16n \
        plodb2=0 plodb3=0 nf_flag=1 smbt=1M smbb=1M dinsaflag=0 ppitch=0 \
        spot=103n spob=103n spotl1=103n spobl1=103n spotl2=103n \
        spobl2=103n spotr1=103n spobr1=103n spotr2=103n spobr2=103n
MP2 (OUTP1 OUTN1 VDD VDD) pch_svt_mac l=16n nfin=2 w=58n multi=1 nf=2 \
        sd=74n sa=90n sb=90n ploda1=16n ploda2=0 ploda3=0 plodb1=16n \
        plodb2=0 plodb3=0 nf_flag=1 smbt=1M smbb=1M dinsaflag=0 ppitch=0 \
        spot=103n spob=103n spotl1=103n spobl1=103n spotl2=103n \
        spobl2=103n spotr1=103n spobr1=103n spotr2=103n spobr2=103n
MP1 (OUTN1 OUTN1 VDD VDD) pch_svt_mac l=16n nfin=2 w=58n multi=1 nf=2 \
        sd=74n sa=90n sb=90n ploda1=16n ploda2=0 ploda3=0 plodb1=16n \
        plodb2=0 plodb3=0 nf_flag=1 smbt=1M smbb=1M dinsaflag=0 ppitch=0 \
        spot=103n spob=103n spotl1=103n spobl1=103n spotl2=103n \
        spobl2=103n spotr1=103n spobr1=103n spotr2=103n spobr2=103n
ends cmp_x
