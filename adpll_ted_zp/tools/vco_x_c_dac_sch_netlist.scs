// adpll_sch/vco_x_c_dac/schematic
MN1 (OUTP OUTN TAIL VSS) nch_ulvt_mac l=16n nfin=2 w=58n multi=1 nf=16 sd=74n sa=90n sb=90n ploda1=16n ploda2=0 ploda3=0 plodb1=16n plodb2=0 plodb3=0 nf_flag=1 smbt=1M smbb=1M dinsaflag=0 ppitch=0 spot=103n spob=103n spotl1=103n spobl1=103n spotl2=103n spobl2=103n spotr1=103n spobr1=103n spotr2=103n spobr2=103n
MN0 (OUTN OUTP TAIL VSS) nch_ulvt_mac l=16n nfin=2 w=58n multi=1 nf=16 sd=74n sa=90n sb=90n ploda1=16n ploda2=0 ploda3=0 plodb1=16n plodb2=0 plodb3=0 nf_flag=1 smbt=1M smbb=1M dinsaflag=0 ppitch=0 spot=103n spob=103n spotl1=103n spobl1=103n spotl2=103n spobl2=103n spotr1=103n spobr1=103n spotr2=103n spobr2=103n
L1 (VDD OUTN) inductor l=1.5n r=2
L0 (VDD OUTP) inductor l=1.5n r=2
Ls (TAIL VSS) inductor l=2n r=1
Cbyp (VDD VSS) capacitor c=10p
CF11 (OUTN net11 VSS) cfmom_wo_p80 dmflag=0 lr=1u multi=1 mxd_flag=0 nr=174 n_mxa=2 shield=2 spm=3 stm=1 vapmod=2 grflag=1 gdis_t=185n gdis_b=185n gdis_l=102n gdis_r=102n
CF10 (OUTN net10 VSS) cfmom_wo_p80 dmflag=0 lr=1u multi=1 mxd_flag=0 nr=174 n_mxa=2 shield=2 spm=3 stm=1 vapmod=2 grflag=1 gdis_t=185n gdis_b=185n gdis_l=102n gdis_r=102n
CF9 (OUTN net09 VSS) cfmom_wo_p80 dmflag=0 lr=1u multi=1 mxd_flag=0 nr=174 n_mxa=2 shield=2 spm=3 stm=1 vapmod=2 grflag=1 gdis_t=185n gdis_b=185n gdis_l=102n gdis_r=102n
CF8 (OUTN net08 VSS) cfmom_wo_p80 dmflag=0 lr=1u multi=1 mxd_flag=0 nr=174 n_mxa=2 shield=2 spm=3 stm=1 vapmod=2 grflag=1 gdis_t=185n gdis_b=185n gdis_l=102n gdis_r=102n
CF7 (OUTN net07 VSS) cfmom_wo_p80 dmflag=0 lr=1u multi=1 mxd_flag=0 nr=174 n_mxa=2 shield=2 spm=3 stm=1 vapmod=2 grflag=1 gdis_t=185n gdis_b=185n gdis_l=102n gdis_r=102n
CF6 (OUTP OUTN VSS) cfmom_wo_p80 dmflag=0 lr=1u multi=1 mxd_flag=0 nr=174 n_mxa=2 shield=2 spm=3 stm=1 vapmod=2 grflag=1 gdis_t=185n gdis_b=185n gdis_l=102n gdis_r=102n
CF5 (OUTN net05 VSS) cfmom_wo_p80 dmflag=0 lr=1u multi=1 mxd_flag=0 nr=174 n_mxa=2 shield=2 spm=3 stm=1 vapmod=2 grflag=1 gdis_t=185n gdis_b=185n gdis_l=102n gdis_r=102n
CF4 (OUTN net04 VSS) cfmom_wo_p80 dmflag=0 lr=1u multi=1 mxd_flag=0 nr=174 n_mxa=2 shield=2 spm=3 stm=1 vapmod=2 grflag=1 gdis_t=185n gdis_b=185n gdis_l=102n gdis_r=102n
CF3 (OUTN net03 VSS) cfmom_wo_p80 dmflag=0 lr=1u multi=1 mxd_flag=0 nr=174 n_mxa=2 shield=2 spm=3 stm=1 vapmod=2 grflag=1 gdis_t=185n gdis_b=185n gdis_l=102n gdis_r=102n
CF2 (OUTN net02 VSS) cfmom_wo_p80 dmflag=0 lr=1u multi=1 mxd_flag=0 nr=174 n_mxa=2 shield=2 spm=3 stm=1 vapmod=2 grflag=1 gdis_t=185n gdis_b=185n gdis_l=102n gdis_r=102n
CF1 (OUTN net01 VSS) cfmom_wo_p80 dmflag=0 lr=1u multi=1 mxd_flag=0 nr=174 n_mxa=2 shield=2 spm=3 stm=1 vapmod=2 grflag=1 gdis_t=185n gdis_b=185n gdis_l=102n gdis_r=102n
CF0 (OUTP OUTN VSS) cfmom_wo_p80 dmflag=0 lr=1u multi=1 mxd_flag=0 nr=174 n_mxa=2 shield=2 spm=3 stm=1 vapmod=2 grflag=1 gdis_t=185n gdis_b=185n gdis_l=102n gdis_r=102n
C2n_mv (OUTN VC2 VC2) moscap_rf wr=538n nfin=2 lr=200n gr=2 br=2 multi=1 sobn=470n sobs=470n sobw=684n sobe=684n
C2p_mv (OUTP VC2 VC2) moscap_rf wr=538n nfin=2 lr=200n gr=2 br=2 multi=1 sobn=470n sobs=470n sobw=684n sobe=684n
C1n_mv (OUTN VC1 VC1) moscap_rf wr=538n nfin=24 lr=200n gr=2 br=2 multi=1 sobn=470n sobs=470n sobw=684n sobe=684n
C1p_mv (OUTP VC1 VC1) moscap_rf wr=538n nfin=24 lr=200n gr=2 br=2 multi=1 sobn=470n sobs=470n sobw=684n sobe=684n
