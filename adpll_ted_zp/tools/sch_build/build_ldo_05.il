cv = dbOpenCellViewByType("adpll_sch" "ldo_05" "schematic" "schematic" "a")

procedure(rsProp(inst prop val)
  if(dbFindProp(inst prop)
    dbReplaceProp(inst prop "string" val)
    dbCreateProp(inst prop "string" val)))

procedure(rsTermCtr(inst termName)
  let((term pin fig bb)
    term = car(setof(tt inst~>master~>terminals tt~>name == termName))
    pin = when(term car(term~>pins))
    fig = when(pin car(pin~>figs))
    bb = when(fig fig~>bBox)
    when(bb
      dbTransformPoint(
        list((xCoord(car(bb)) + xCoord(cadr(bb))) / 2.0
             (yCoord(car(bb)) + yCoord(cadr(bb))) / 2.0)
        inst~>transform))))

procedure(rsStub(inst termName netName dx dy)
  let((ctr end mid)
    ctr = rsTermCtr(inst termName)
    when(ctr
      end = list(xCoord(ctr) + dx yCoord(ctr) + dy)
      mid = list((xCoord(ctr) + xCoord(end)) / 2.0
                 (yCoord(ctr) + yCoord(end)) / 2.0)
      schCreateWire(cv "route" "full" list(ctr end) 0 0 0 nil nil)
      schCreateWireLabel(cv nil mid netName "centerCenter" "R0" "stick" 0.0625 nil))))

procedure(rsPinAt(pinName dir x y)
  let((master)
    master = dbOpenCellViewByType("basic"
      cond((dir == "input" "ipin") (dir == "output" "opin") (t "iopin"))
      "symbol")
    schCreatePin(cv master pinName dir nil x:y "R0")
    schCreateWire(cv "route" "full" list(x:y x+0.5:y) 0 0 0 nil nil)
    schCreateWireLabel(cv nil x+0.25:y pinName "centerCenter" "R0" "stick" 0.0625 nil)))
; ---- 5T OTA + pass + RC ----
MN1 = dbCreateInstByMasterName(cv "tsmcN12" "nch_ulvt_mac" "symbol" "MN1" 6:8 "R0")
rsProp(MN1 "fingers" "4") rsProp(MN1 "nf" "4")
MN2 = dbCreateInstByMasterName(cv "tsmcN12" "nch_ulvt_mac" "symbol" "MN2" 10:8 "R0")
rsProp(MN2 "fingers" "4") rsProp(MN2 "nf" "4")
MTAIL = dbCreateInstByMasterName(cv "tsmcN12" "nch_ulvt_mac" "symbol" "MTAIL" 8:4 "R0")
rsProp(MTAIL "fingers" "1") rsProp(MTAIL "nf" "1")
MP1 = dbCreateInstByMasterName(cv "tsmcN12" "pch_svt_mac" "symbol" "MP1" 6:13 "R0")
rsProp(MP1 "fingers" "2") rsProp(MP1 "nf" "2")
MP2 = dbCreateInstByMasterName(cv "tsmcN12" "pch_svt_mac" "symbol" "MP2" 10:13 "R0")
rsProp(MP2 "fingers" "2") rsProp(MP2 "nf" "2")
MPASS = dbCreateInstByMasterName(cv "tsmcN12" "pch_svt_mac" "symbol" "MPASS" 15:9 "R0")
rsProp(MPASS "fingers" "256") rsProp(MPASS "nf" "256")
RLPF = dbCreateInstByMasterName(cv "analogLib" "res" "symbol" "RLPF" 18:12 "R0")
rsProp(RLPF "r" "2k")
CLPF = dbCreateInstByMasterName(cv "analogLib" "cap" "symbol" "CLPF" 18:5 "R0")
rsProp(CLPF "c" "2p")
COUT = dbCreateInstByMasterName(cv "analogLib" "cap" "symbol" "COUT" 21:9 "R0")
rsProp(COUT "c" "20p")

rsStub(MN1 "D" "VDN" 0.25 0) rsStub(MN1 "G" "VOUT" -0.25 0)
rsStub(MN1 "S" "TAIL" 0 -0.25) rsStub(MN1 "B" "VSS" 0.25 0)
rsStub(MN2 "D" "VDP" 0.25 0) rsStub(MN2 "G" "VBG" -0.25 0)
rsStub(MN2 "S" "TAIL" 0 -0.25) rsStub(MN2 "B" "VSS" 0.25 0)
rsStub(MTAIL "D" "TAIL" 0 0.25) rsStub(MTAIL "G" "VBL" -0.25 0)
rsStub(MTAIL "S" "VSS" 0 -0.25) rsStub(MTAIL "B" "VSS" 0.25 0)
rsStub(MP1 "D" "VDN" 0 -0.25) rsStub(MP1 "G" "VDN" -0.25 0)
rsStub(MP1 "S" "VDD" 0 0.25) rsStub(MP1 "B" "VDD" 0.25 0)
rsStub(MP2 "D" "VDP" 0 -0.25) rsStub(MP2 "G" "VDN" -0.25 0)
rsStub(MP2 "S" "VDD" 0 0.25) rsStub(MP2 "B" "VDD" 0.25 0)
rsStub(MPASS "D" "VOUT" 0 -0.25) rsStub(MPASS "G" "VGATE" -0.25 0)
rsStub(MPASS "S" "VIN" 0 0.25) rsStub(MPASS "B" "VIN" 0.25 0)
rsStub(RLPF "PLUS" "VDP" 0 0.25) rsStub(RLPF "MINUS" "VGATE" 0 -0.25)
rsStub(CLPF "PLUS" "VGATE" 0 0.25) rsStub(CLPF "MINUS" "VSS" 0 -0.25)
rsStub(COUT "PLUS" "VOUT" 0 0.25) rsStub(COUT "MINUS" "VSS" 0 -0.25)

; pins in subckt header order: VDD VIN VBG VBL VOUT VSS
rsPinAt("VDD" "inputOutput" 1.0 18.0)
rsPinAt("VIN" "inputOutput" 1.0 16.0)
rsPinAt("VBG" "input" 1.0 14.0)
rsPinAt("VBL" "input" 1.0 12.0)
rsPinAt("VOUT" "output" 1.0 10.0)
rsPinAt("VSS" "inputOutput" 1.0 8.0)

printf("LDO_BUILD_DONE instances=%d\n" length(cv~>instances))
