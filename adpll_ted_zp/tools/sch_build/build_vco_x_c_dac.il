cv = dbOpenCellViewByType("adpll_sch" "vco_x_c_dac" "schematic" "schematic" "a")

procedure(rsProp(inst prop val)
  if(dbFindProp(inst prop)
    dbReplaceProp(inst prop "string" val)
    dbCreateProp(inst prop "string" val)))

procedure(rsTermCtr(inst termName)
  let((term pin fig bb)
    term = car(setof(tt inst~>master~>terminals tt~>name == termName))
    pin = when(term car(term~>pins))
    fig = when(pin car(pin~>figs))
    bb = when(fig fig~>bBox)
    when(bb
      dbTransformPoint(
        list((xCoord(car(bb)) + xCoord(cadr(bb))) / 2.0
             (yCoord(car(bb)) + yCoord(cadr(bb))) / 2.0)
        inst~>transform))))

procedure(rsStub(inst termName netName dx dy)
  let((ctr end mid)
    ctr = rsTermCtr(inst termName)
    when(ctr
      end = list(xCoord(ctr) + dx yCoord(ctr) + dy)
      mid = list((xCoord(ctr) + xCoord(end)) / 2.0
                 (yCoord(ctr) + yCoord(end)) / 2.0)
      schCreateWire(cv "route" "full" list(ctr end) 0 0 0 nil nil)
      schCreateWireLabel(cv nil mid netName "centerCenter" "R0" "stick" 0.0625 nil))))

procedure(rsPinAt(pinName dir x y)
  let((master)
    master = dbOpenCellViewByType("basic"
      cond((dir == "input" "ipin") (dir == "output" "opin") (t "iopin"))
      "symbol")
    schCreatePin(cv master pinName dir nil x:y "R0")
    schCreateWire(cv "route" "full" list(x:y x+0.5:y) 0 0 0 nil nil)
    schCreateWireLabel(cv nil x+0.25:y pinName "centerCenter" "R0" "stick" 0.0625 nil)))
; ---- cross-coupled pair + tank ----
MN0 = dbCreateInstByMasterName(cv "tsmcN12" "nch_ulvt_mac" "symbol" "MN0" 6:10 "R0")
rsProp(MN0 "fingers" "16") rsProp(MN0 "nf" "16")
MN1 = dbCreateInstByMasterName(cv "tsmcN12" "nch_ulvt_mac" "symbol" "MN1" 10:10 "R0")
rsProp(MN1 "fingers" "16") rsProp(MN1 "nf" "16")
Ls = dbCreateInstByMasterName(cv "analogLib" "ind" "symbol" "Ls" 8:5 "R0")
rsProp(Ls "l" "2n")
rsProp(Ls "r" "1")
L0 = dbCreateInstByMasterName(cv "analogLib" "ind" "symbol" "L0" 4:15 "R0")
rsProp(L0 "l" "1.5n")
rsProp(L0 "r" "2")
L1 = dbCreateInstByMasterName(cv "analogLib" "ind" "symbol" "L1" 10:15 "R0")
rsProp(L1 "l" "1.5n")
rsProp(L1 "r" "2")
Cbyp = dbCreateInstByMasterName(cv "analogLib" "cap" "symbol" "Cbyp" 2:9 "R0")
rsProp(Cbyp "c" "10p")
CF0 = dbCreateInstByMasterName(cv "tsmcN12" "cfmom_wo_p80" "symbol" "CF0" 4.0:2 "R0")
rsProp(CF0 "nr" "174")
rsStub(CF0 "PLUS" "OUTP" 0 0.25)
rsStub(CF0 "MINUS" "OUTN" 0 -0.25)
rsStub(CF0 "BULK" "VSS" 0.25 0)
CF1 = dbCreateInstByMasterName(cv "tsmcN12" "cfmom_wo_p80" "symbol" "CF1" 6.5:2 "R0")
rsProp(CF1 "nr" "174")
rsStub(CF1 "PLUS" "OUTN" 0 0.25)
rsStub(CF1 "MINUS" "net01" 0 -0.25)
rsStub(CF1 "BULK" "VSS" 0.25 0)
CF2 = dbCreateInstByMasterName(cv "tsmcN12" "cfmom_wo_p80" "symbol" "CF2" 9.0:2 "R0")
rsProp(CF2 "nr" "174")
rsStub(CF2 "PLUS" "OUTN" 0 0.25)
rsStub(CF2 "MINUS" "net02" 0 -0.25)
rsStub(CF2 "BULK" "VSS" 0.25 0)
CF3 = dbCreateInstByMasterName(cv "tsmcN12" "cfmom_wo_p80" "symbol" "CF3" 11.5:2 "R0")
rsProp(CF3 "nr" "174")
rsStub(CF3 "PLUS" "OUTN" 0 0.25)
rsStub(CF3 "MINUS" "net03" 0 -0.25)
rsStub(CF3 "BULK" "VSS" 0.25 0)
CF4 = dbCreateInstByMasterName(cv "tsmcN12" "cfmom_wo_p80" "symbol" "CF4" 14.0:2 "R0")
rsProp(CF4 "nr" "174")
rsStub(CF4 "PLUS" "OUTN" 0 0.25)
rsStub(CF4 "MINUS" "net04" 0 -0.25)
rsStub(CF4 "BULK" "VSS" 0.25 0)
CF5 = dbCreateInstByMasterName(cv "tsmcN12" "cfmom_wo_p80" "symbol" "CF5" 16.5:2 "R0")
rsProp(CF5 "nr" "174")
rsStub(CF5 "PLUS" "OUTN" 0 0.25)
rsStub(CF5 "MINUS" "net05" 0 -0.25)
rsStub(CF5 "BULK" "VSS" 0.25 0)
CF6 = dbCreateInstByMasterName(cv "tsmcN12" "cfmom_wo_p80" "symbol" "CF6" 19.0:2 "R0")
rsProp(CF6 "nr" "174")
rsStub(CF6 "PLUS" "OUTP" 0 0.25)
rsStub(CF6 "MINUS" "OUTN" 0 -0.25)
rsStub(CF6 "BULK" "VSS" 0.25 0)
CF7 = dbCreateInstByMasterName(cv "tsmcN12" "cfmom_wo_p80" "symbol" "CF7" 21.5:2 "R0")
rsProp(CF7 "nr" "174")
rsStub(CF7 "PLUS" "OUTN" 0 0.25)
rsStub(CF7 "MINUS" "net07" 0 -0.25)
rsStub(CF7 "BULK" "VSS" 0.25 0)
CF8 = dbCreateInstByMasterName(cv "tsmcN12" "cfmom_wo_p80" "symbol" "CF8" 24.0:2 "R0")
rsProp(CF8 "nr" "174")
rsStub(CF8 "PLUS" "OUTN" 0 0.25)
rsStub(CF8 "MINUS" "net08" 0 -0.25)
rsStub(CF8 "BULK" "VSS" 0.25 0)
CF9 = dbCreateInstByMasterName(cv "tsmcN12" "cfmom_wo_p80" "symbol" "CF9" 26.5:2 "R0")
rsProp(CF9 "nr" "174")
rsStub(CF9 "PLUS" "OUTN" 0 0.25)
rsStub(CF9 "MINUS" "net09" 0 -0.25)
rsStub(CF9 "BULK" "VSS" 0.25 0)
CF10 = dbCreateInstByMasterName(cv "tsmcN12" "cfmom_wo_p80" "symbol" "CF10" 29.0:2 "R0")
rsProp(CF10 "nr" "174")
rsStub(CF10 "PLUS" "OUTN" 0 0.25)
rsStub(CF10 "MINUS" "net10" 0 -0.25)
rsStub(CF10 "BULK" "VSS" 0.25 0)
CF11 = dbCreateInstByMasterName(cv "tsmcN12" "cfmom_wo_p80" "symbol" "CF11" 31.5:2 "R0")
rsProp(CF11 "nr" "174")
rsStub(CF11 "PLUS" "OUTN" 0 0.25)
rsStub(CF11 "MINUS" "net11" 0 -0.25)
rsStub(CF11 "BULK" "VSS" 0.25 0)
C1p_mv = dbCreateInstByMasterName(cv "tsmcN12" "moscap_rf" "symbol" "C1p_mv" 19:14 "R0")
rsProp(C1p_mv "wr" "538n")
rsProp(C1p_mv "nfin" "24")
rsProp(C1p_mv "lr" "200n")
C1n_mv = dbCreateInstByMasterName(cv "tsmcN12" "moscap_rf" "symbol" "C1n_mv" 23:14 "R0")
rsProp(C1n_mv "wr" "538n")
rsProp(C1n_mv "nfin" "24")
rsProp(C1n_mv "lr" "200n")
C2p_mv = dbCreateInstByMasterName(cv "tsmcN12" "moscap_rf" "symbol" "C2p_mv" 19:11 "R0")
rsProp(C2p_mv "wr" "538n")
rsProp(C2p_mv "nfin" "2")
rsProp(C2p_mv "lr" "200n")
C2n_mv = dbCreateInstByMasterName(cv "tsmcN12" "moscap_rf" "symbol" "C2n_mv" 23:11 "R0")
rsProp(C2n_mv "wr" "538n")
rsProp(C2n_mv "nfin" "2")
rsProp(C2n_mv "lr" "200n")

rsStub(MN0 "D" "OUTN" 0 0.25) rsStub(MN0 "G" "OUTP" -0.25 0)
rsStub(MN0 "S" "TAIL" 0 -0.25) rsStub(MN0 "B" "VSS" 0.25 0)
rsStub(MN1 "D" "OUTP" 0 0.25) rsStub(MN1 "G" "OUTN" -0.25 0)
rsStub(MN1 "S" "TAIL" 0 -0.25) rsStub(MN1 "B" "VSS" 0.25 0)
rsStub(Ls "PLUS" "TAIL" 0 0.25) rsStub(Ls "MINUS" "VSS" 0 -0.25)
rsStub(L0 "PLUS" "VDD" 0 0.25) rsStub(L0 "MINUS" "OUTP" 0 -0.25)
rsStub(L1 "PLUS" "VDD" 0 0.25) rsStub(L1 "MINUS" "OUTN" 0 -0.25)
rsStub(Cbyp "PLUS" "VDD" 0 0.25) rsStub(Cbyp "MINUS" "VSS" 0 -0.25)

rsStub(C1p_mv "GATE" "OUTP" -0.25 0) rsStub(C1p_mv "BULK" "VC1" 0 -0.25)
rsStub(C1p_mv "GNODE" "VC1" 0.25 0)
rsStub(C1n_mv "GATE" "OUTN" 0 0.25) rsStub(C1n_mv "BULK" "VC1" 0 -0.25)
rsStub(C1n_mv "GNODE" "VC1" 0.25 0)
rsStub(C2p_mv "GATE" "OUTP" -0.25 0) rsStub(C2p_mv "BULK" "VC2" 0 -0.25)
rsStub(C2p_mv "GNODE" "VC2" 0.25 0)
rsStub(C2n_mv "GATE" "OUTN" 0 0.25) rsStub(C2n_mv "BULK" "VC2" 0 -0.25)
rsStub(C2n_mv "GNODE" "VC2" 0.25 0)

; pins in subckt header order: VDD VDDC VSS OUTP OUTN VC1 VC2
; (VDDC port is vestigial in reference netlist - stays unconnected inside)
rsPinAt("VDD" "inputOutput" 1.0 20.0)
rsPinAt("VDDC" "inputOutput" 1.0 18.0)
rsPinAt("VSS" "inputOutput" 1.0 16.0)
rsPinAt("OUTP" "output" 1.0 14.0)
rsPinAt("OUTN" "output" 1.0 12.0)
rsPinAt("VC1" "input" 1.0 10.0)
rsPinAt("VC2" "input" 1.0 8.0)

printf("VCO_BUILD_DONE instances=%d\n" length(cv~>instances))
