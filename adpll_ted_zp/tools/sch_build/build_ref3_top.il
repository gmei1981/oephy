cv = dbOpenCellViewByType("adpll_sch" "adpll_ref3_top" "schematic" "schematic" "a")

procedure(rsProp(inst prop val)
  if(dbFindProp(inst prop)
    dbReplaceProp(inst prop "string" val)
    dbCreateProp(inst prop "string" val)))

procedure(rsTermCtr(inst termName)
  let((term pin fig bb)
    term = car(setof(tt inst~>master~>terminals tt~>name == termName))
    pin = when(term car(term~>pins))
    fig = when(pin car(pin~>figs))
    bb = when(fig fig~>bBox)
    when(bb
      dbTransformPoint(
        list((xCoord(car(bb)) + xCoord(cadr(bb))) / 2.0
             (yCoord(car(bb)) + yCoord(cadr(bb))) / 2.0)
        inst~>transform))))

procedure(rsStub(inst termName netName dx dy)
  let((ctr end mid)
    ctr = rsTermCtr(inst termName)
    when(ctr
      end = list(xCoord(ctr) + dx yCoord(ctr) + dy)
      mid = list((xCoord(ctr) + xCoord(end)) / 2.0
                 (yCoord(ctr) + yCoord(end)) / 2.0)
      schCreateWire(cv "route" "full" list(ctr end) 0 0 0 nil nil)
      schCreateWireLabel(cv nil mid netName "centerCenter" "R0" "stick" 0.0625 nil))))

procedure(rsPinAt(pinName dir x y)
  let((master)
    master = dbOpenCellViewByType("basic"
      cond((dir == "input" "ipin") (dir == "output" "opin") (t "iopin"))
      "symbol")
    schCreatePin(cv master pinName dir nil x:y "R0")
    schCreateWire(cv "route" "full" list(x:y x+0.5:y) 0 0 0 nil nil)
    schCreateWireLabel(cv nil x+0.25:y pinName "centerCenter" "R0" "stick" 0.0625 nil)))
Xfsm = dbCreateInstByMasterName(cv "adpll_sch" "pll_fsm" "symbol" "Xfsm" 60:20 "R0")
rsProp(Xfsm "idle_wait" "4")
rsStub(Xfsm "clk" "REF" -0.35 0)
rsStub(Xfsm "rstn" "RSTN" -0.35 0)
rsStub(Xfsm "afc_finish" "AFCD" -0.35 0)
rsStub(Xfsm "freq_lock" "FQLK" -0.35 0)
rsStub(Xfsm "phase_lock" "PHLK" -0.35 0)
rsStub(Xfsm "st0" "ST0" 0.35 0)
rsStub(Xfsm "st1" "ST1" 0.35 0)
rsStub(Xfsm "st2" "ST2" 0.35 0)
rsStub(Xfsm "en_afc" "ENA" 0.35 0)
rsStub(Xfsm "en_fll" "ENF" 0.35 0)
rsStub(Xfsm "en_pll" "ENP" 0.35 0)
rsStub(Xfsm "state" "FSTATE" 0.35 0)

Xlock = dbCreateInstByMasterName(cv "adpll_sch" "pll_lockdet" "symbol" "Xlock" 48:20 "R0")
rsProp(Xlock "lock_thr" "0.02")
rsStub(Xlock "clk" "REF" -0.35 0)
rsStub(Xlock "phe" "PHE" -0.35 0)
rsStub(Xlock "phase_lock" "PHLK" 0.35 0)

Xdsmf = dbCreateInstByMasterName(cv "adpll_sch" "pll_dsm_fb" "symbol" "Xdsmf" 72:20 "R0")
rsProp(Xdsmf "FCW" "80.0")
rsProp(Xdsmf "dsm_fb_mode" "0")
rsStub(Xdsmf "clk" "REF" -0.35 0)
rsStub(Xdsmf "rcomp" "RCOMP" -0.35 0)
rsStub(Xdsmf "p0" "P0" 0.35 0)
rsStub(Xdsmf "p1" "P1" 0.35 0)
rsStub(Xdsmf "p2" "P2" 0.35 0)
rsStub(Xdsmf "p3" "P3" 0.35 0)
rsStub(Xdsmf "p4" "P4" 0.35 0)
rsStub(Xdsmf "p5" "P5" 0.35 0)
rsStub(Xdsmf "p6" "P6" 0.35 0)
rsStub(Xdsmf "p7" "P7" 0.35 0)
rsStub(Xdsmf "p8" "P8" 0.35 0)
rsStub(Xdsmf "p9" "P9" 0.35 0)
rsStub(Xdsmf "p10" "P10" 0.35 0)
rsStub(Xdsmf "p11" "P11" 0.35 0)
rsStub(Xdsmf "p12" "P12" 0.35 0)
rsStub(Xdsmf "q_err" "QERR" 0.35 0)
rsStub(Xdsmf "sel" "SELF" 0.35 0)

Xmmd = dbCreateInstByMasterName(cv "adpll_sch" "pll_mmd_ps" "symbol" "Xmmd" 84:20 "R0")
rsProp(Xmmd "ninit" "80")
rsStub(Xmmd "vco_in" "OUTPB" -0.35 0)
rsStub(Xmmd "p0" "P0" -0.35 0)
rsStub(Xmmd "p1" "P1" -0.35 0)
rsStub(Xmmd "p2" "P2" -0.35 0)
rsStub(Xmmd "p3" "P3" -0.35 0)
rsStub(Xmmd "p4" "P4" -0.35 0)
rsStub(Xmmd "p5" "P5" -0.35 0)
rsStub(Xmmd "p6" "P6" -0.35 0)
rsStub(Xmmd "p7" "P7" -0.35 0)
rsStub(Xmmd "p8" "P8" -0.35 0)
rsStub(Xmmd "p9" "P9" -0.35 0)
rsStub(Xmmd "p10" "P10" -0.35 0)
rsStub(Xmmd "p11" "P11" -0.35 0)
rsStub(Xmmd "p12" "P12" -0.35 0)
rsStub(Xmmd "sel" "SELF" -0.35 0)
rsStub(Xmmd "ckfb" "CKFB" 0.35 0)

Xdivn = dbCreateInstByMasterName(cv "adpll_sch" "pll_divn" "symbol" "Xdivn" 96:20 "R0")
rsProp(Xdivn "N" "8")
rsStub(Xdivn "in" "OUTPB" -0.35 0)
rsStub(Xdivn "out" "CK16" 0.35 0)

Xtdc = dbCreateInstByMasterName(cv "adpll_sch" "pll_tdc_beh" "symbol" "Xtdc" 0:20 "R0")
rsStub(Xtdc "ckr" "CKR" -0.35 0)
rsStub(Xtdc "ckfb" "CKFB" -0.35 0)
rsStub(Xtdc "oha0" "OHA0" -0.35 0)
rsStub(Xtdc "oha1" "OHA1" -0.35 0)
rsStub(Xtdc "oha2" "OHA2" -0.35 0)
rsStub(Xtdc "oha3" "OHA3" -0.35 0)
rsStub(Xtdc "oha4" "OHA4" -0.35 0)
rsStub(Xtdc "oha5" "OHA5" -0.35 0)
rsStub(Xtdc "oha6" "OHA6" -0.35 0)
rsStub(Xtdc "oha7" "OHA7" -0.35 0)
rsStub(Xtdc "oha8" "OHA8" -0.35 0)
rsStub(Xtdc "oha9" "OHA9" -0.35 0)
rsStub(Xtdc "oha10" "OHA10" -0.35 0)
rsStub(Xtdc "oha11" "OHA11" -0.35 0)
rsStub(Xtdc "oha12" "OHA12" -0.35 0)
rsStub(Xtdc "oha13" "OHA13" -0.35 0)
rsStub(Xtdc "oha14" "OHA14" -0.35 0)
rsStub(Xtdc "oha15" "OHA15" -0.35 0)
rsStub(Xtdc "ohb0" "OHB0" -0.35 0)
rsStub(Xtdc "ohb1" "OHB1" -0.35 0)
rsStub(Xtdc "ohb2" "OHB2" -0.35 0)
rsStub(Xtdc "ohb3" "OHB3" -0.35 0)
rsStub(Xtdc "ohb4" "OHB4" -0.35 0)
rsStub(Xtdc "ohb5" "OHB5" -0.35 0)
rsStub(Xtdc "ohb6" "OHB6" -0.35 0)
rsStub(Xtdc "ohb7" "OHB7" -0.35 0)
rsStub(Xtdc "ohb8" "OHB8" -0.35 0)
rsStub(Xtdc "ohb9" "OHB9" -0.35 0)
rsStub(Xtdc "ohb10" "OHB10" -0.35 0)
rsStub(Xtdc "ohb11" "OHB11" -0.35 0)
rsStub(Xtdc "ohb12" "OHB12" -0.35 0)
rsStub(Xtdc "ohb13" "OHB13" -0.35 0)
rsStub(Xtdc "ohb14" "OHB14" -0.35 0)
rsStub(Xtdc "ohb15" "OHB15" -0.35 0)
rsStub(Xtdc "ca0" "CA0" 0.35 0)
rsStub(Xtdc "ca1" "CA1" 0.35 0)
rsStub(Xtdc "ca2" "CA2" 0.35 0)
rsStub(Xtdc "ca3" "CA3" 0.35 0)
rsStub(Xtdc "ca4" "CA4" 0.35 0)
rsStub(Xtdc "ca5" "CA5" 0.35 0)
rsStub(Xtdc "ca6" "CA6" 0.35 0)
rsStub(Xtdc "ca7" "CA7" 0.35 0)
rsStub(Xtdc "ca8" "CA8" 0.35 0)
rsStub(Xtdc "ca9" "CA9" 0.35 0)
rsStub(Xtdc "ca10" "CA10" 0.35 0)
rsStub(Xtdc "ca11" "CA11" 0.35 0)
rsStub(Xtdc "ca12" "CA12" 0.35 0)
rsStub(Xtdc "ca13" "CA13" 0.35 0)
rsStub(Xtdc "ca14" "CA14" 0.35 0)
rsStub(Xtdc "ca15" "CA15" 0.35 0)
rsStub(Xtdc "cb0" "CB0" 0.35 0)
rsStub(Xtdc "cb1" "CB1" 0.35 0)
rsStub(Xtdc "cb2" "CB2" 0.35 0)
rsStub(Xtdc "cb3" "CB3" 0.35 0)
rsStub(Xtdc "cb4" "CB4" 0.35 0)
rsStub(Xtdc "cb5" "CB5" 0.35 0)
rsStub(Xtdc "cb6" "CB6" 0.35 0)
rsStub(Xtdc "cb7" "CB7" 0.35 0)
rsStub(Xtdc "cb8" "CB8" 0.35 0)
rsStub(Xtdc "cb9" "CB9" 0.35 0)
rsStub(Xtdc "cb10" "CB10" 0.35 0)
rsStub(Xtdc "cb11" "CB11" 0.35 0)
rsStub(Xtdc "cb12" "CB12" 0.35 0)
rsStub(Xtdc "cb13" "CB13" 0.35 0)
rsStub(Xtdc "cb14" "CB14" 0.35 0)
rsStub(Xtdc "cb15" "CB15" 0.35 0)
rsStub(Xtdc "f0" "FT0" 0.35 0)
rsStub(Xtdc "f1" "FT1" 0.35 0)
rsStub(Xtdc "f2" "FT2" 0.35 0)
rsStub(Xtdc "f3" "FT3" 0.35 0)
rsStub(Xtdc "f4" "FT4" 0.35 0)
rsStub(Xtdc "f5" "FT5" 0.35 0)
rsStub(Xtdc "f6" "FT6" 0.35 0)
rsStub(Xtdc "f7" "FT7" 0.35 0)
rsStub(Xtdc "f8" "FT8" 0.35 0)
rsStub(Xtdc "f9" "FT9" 0.35 0)
rsStub(Xtdc "f10" "FT10" 0.35 0)
rsStub(Xtdc "f11" "FT11" 0.35 0)
rsStub(Xtdc "f12" "FT12" 0.35 0)
rsStub(Xtdc "f13" "FT13" 0.35 0)
rsStub(Xtdc "f14" "FT14" 0.35 0)
rsStub(Xtdc "f15" "FT15" 0.35 0)
rsStub(Xtdc "arb" "ARB" 0.35 0)

Xpfd = dbCreateInstByMasterName(cv "adpll_sch" "pll_pfd" "symbol" "Xpfd" 12:20 "R0")
rsStub(Xpfd "ca0" "CA0" -0.35 0)
rsStub(Xpfd "ca1" "CA1" -0.35 0)
rsStub(Xpfd "ca2" "CA2" -0.35 0)
rsStub(Xpfd "ca3" "CA3" -0.35 0)
rsStub(Xpfd "ca4" "CA4" -0.35 0)
rsStub(Xpfd "ca5" "CA5" -0.35 0)
rsStub(Xpfd "ca6" "CA6" -0.35 0)
rsStub(Xpfd "ca7" "CA7" -0.35 0)
rsStub(Xpfd "ca8" "CA8" -0.35 0)
rsStub(Xpfd "ca9" "CA9" -0.35 0)
rsStub(Xpfd "ca10" "CA10" -0.35 0)
rsStub(Xpfd "ca11" "CA11" -0.35 0)
rsStub(Xpfd "ca12" "CA12" -0.35 0)
rsStub(Xpfd "ca13" "CA13" -0.35 0)
rsStub(Xpfd "ca14" "CA14" -0.35 0)
rsStub(Xpfd "ca15" "CA15" -0.35 0)
rsStub(Xpfd "cb0" "CB0" -0.35 0)
rsStub(Xpfd "cb1" "CB1" -0.35 0)
rsStub(Xpfd "cb2" "CB2" -0.35 0)
rsStub(Xpfd "cb3" "CB3" -0.35 0)
rsStub(Xpfd "cb4" "CB4" -0.35 0)
rsStub(Xpfd "cb5" "CB5" -0.35 0)
rsStub(Xpfd "cb6" "CB6" -0.35 0)
rsStub(Xpfd "cb7" "CB7" -0.35 0)
rsStub(Xpfd "cb8" "CB8" -0.35 0)
rsStub(Xpfd "cb9" "CB9" -0.35 0)
rsStub(Xpfd "cb10" "CB10" -0.35 0)
rsStub(Xpfd "cb11" "CB11" -0.35 0)
rsStub(Xpfd "cb12" "CB12" -0.35 0)
rsStub(Xpfd "cb13" "CB13" -0.35 0)
rsStub(Xpfd "cb14" "CB14" -0.35 0)
rsStub(Xpfd "cb15" "CB15" -0.35 0)
rsStub(Xpfd "f0" "FT0" -0.35 0)
rsStub(Xpfd "f1" "FT1" -0.35 0)
rsStub(Xpfd "f2" "FT2" -0.35 0)
rsStub(Xpfd "f3" "FT3" -0.35 0)
rsStub(Xpfd "f4" "FT4" -0.35 0)
rsStub(Xpfd "f5" "FT5" -0.35 0)
rsStub(Xpfd "f6" "FT6" -0.35 0)
rsStub(Xpfd "f7" "FT7" -0.35 0)
rsStub(Xpfd "f8" "FT8" -0.35 0)
rsStub(Xpfd "f9" "FT9" -0.35 0)
rsStub(Xpfd "f10" "FT10" -0.35 0)
rsStub(Xpfd "f11" "FT11" -0.35 0)
rsStub(Xpfd "f12" "FT12" -0.35 0)
rsStub(Xpfd "f13" "FT13" -0.35 0)
rsStub(Xpfd "f14" "FT14" -0.35 0)
rsStub(Xpfd "f15" "FT15" -0.35 0)
rsStub(Xpfd "arb" "ARB" -0.35 0)
rsStub(Xpfd "oha0" "OHA0" 0.35 0)
rsStub(Xpfd "oha1" "OHA1" 0.35 0)
rsStub(Xpfd "oha2" "OHA2" 0.35 0)
rsStub(Xpfd "oha3" "OHA3" 0.35 0)
rsStub(Xpfd "oha4" "OHA4" 0.35 0)
rsStub(Xpfd "oha5" "OHA5" 0.35 0)
rsStub(Xpfd "oha6" "OHA6" 0.35 0)
rsStub(Xpfd "oha7" "OHA7" 0.35 0)
rsStub(Xpfd "oha8" "OHA8" 0.35 0)
rsStub(Xpfd "oha9" "OHA9" 0.35 0)
rsStub(Xpfd "oha10" "OHA10" 0.35 0)
rsStub(Xpfd "oha11" "OHA11" 0.35 0)
rsStub(Xpfd "oha12" "OHA12" 0.35 0)
rsStub(Xpfd "oha13" "OHA13" 0.35 0)
rsStub(Xpfd "oha14" "OHA14" 0.35 0)
rsStub(Xpfd "oha15" "OHA15" 0.35 0)
rsStub(Xpfd "ohb0" "OHB0" 0.35 0)
rsStub(Xpfd "ohb1" "OHB1" 0.35 0)
rsStub(Xpfd "ohb2" "OHB2" 0.35 0)
rsStub(Xpfd "ohb3" "OHB3" 0.35 0)
rsStub(Xpfd "ohb4" "OHB4" 0.35 0)
rsStub(Xpfd "ohb5" "OHB5" 0.35 0)
rsStub(Xpfd "ohb6" "OHB6" 0.35 0)
rsStub(Xpfd "ohb7" "OHB7" 0.35 0)
rsStub(Xpfd "ohb8" "OHB8" 0.35 0)
rsStub(Xpfd "ohb9" "OHB9" 0.35 0)
rsStub(Xpfd "ohb10" "OHB10" 0.35 0)
rsStub(Xpfd "ohb11" "OHB11" 0.35 0)
rsStub(Xpfd "ohb12" "OHB12" 0.35 0)
rsStub(Xpfd "ohb13" "OHB13" 0.35 0)
rsStub(Xpfd "ohb14" "OHB14" 0.35 0)
rsStub(Xpfd "ohb15" "OHB15" 0.35 0)
rsStub(Xpfd "phe" "PHE" 0.35 0)
rsStub(Xpfd "tcode" "TCODE" 0.35 0)

Xafc = dbCreateInstByMasterName(cv "adpll_sch" "pll_afc6" "symbol" "Xafc" 24:20 "R0")
rsProp(Xafc "FCW" "80.0")
rsProp(Xafc "thr" "7")
rsProp(Xafc "D" "16")
rsStub(Xafc "ref" "REF" -0.35 0)
rsStub(Xafc "ckfb16" "CK16" -0.35 0)
rsStub(Xafc "en" "ENA" -0.35 0)
rsStub(Xafc "p0" "PB0" 0.35 0)
rsStub(Xafc "p1" "PB1" 0.35 0)
rsStub(Xafc "p2" "PB2" 0.35 0)
rsStub(Xafc "p3" "PB3" 0.35 0)
rsStub(Xafc "p4" "PB4" 0.35 0)
rsStub(Xafc "p5" "PB5" 0.35 0)
rsStub(Xafc "afc_done" "AFCD" 0.35 0)
rsStub(Xafc "cnt_out" "CNTOUT" 0.35 0)

Xfll = dbCreateInstByMasterName(cv "adpll_sch" "pll_fll" "symbol" "Xfll" 36:20 "R0")
rsProp(Xfll "FCW" "80.0")
rsProp(Xfll "thr" "8")
rsProp(Xfll "D" "16")
rsProp(Xfll "ftol" "4")
rsStub(Xfll "clk" "REF" -0.35 0)
rsStub(Xfll "ckfb16" "CK16" -0.35 0)
rsStub(Xfll "en_fll" "ENF" -0.35 0)
rsStub(Xfll "freq_ctrl" "FCTRL" 0.35 0)
rsStub(Xfll "freq_lock" "FQLK" 0.35 0)

Xlpf = dbCreateInstByMasterName(cv "adpll_sch" "pll_lpf" "symbol" "Xlpf" 0:-2 "R0")
rsStub(Xlpf "clk" "REF" -0.35 0)
rsStub(Xlpf "phe" "PHE" -0.35 0)
rsStub(Xlpf "freq_ctrl" "FCTRL" -0.35 0)
rsStub(Xlpf "en_afc" "ENA" -0.35 0)
rsStub(Xlpf "en_fll" "ENF" -0.35 0)
rsStub(Xlpf "en_pll" "ENP" -0.35 0)
rsStub(Xlpf "phase_lock" "PHLK" -0.35 0)
rsStub(Xlpf "a0" "PB0" -0.35 0)
rsStub(Xlpf "a1" "PB1" -0.35 0)
rsStub(Xlpf "a2" "PB2" -0.35 0)
rsStub(Xlpf "a3" "PB3" -0.35 0)
rsStub(Xlpf "a4" "PB4" -0.35 0)
rsStub(Xlpf "a5" "PB5" -0.35 0)
rsStub(Xlpf "ab0" "AB0" 0.35 0)
rsStub(Xlpf "ab1" "AB1" 0.35 0)
rsStub(Xlpf "ab2" "AB2" 0.35 0)
rsStub(Xlpf "ab3" "AB3" 0.35 0)
rsStub(Xlpf "ab4" "AB4" 0.35 0)
rsStub(Xlpf "ab5" "AB5" 0.35 0)
rsStub(Xlpf "ab6" "AB6" 0.35 0)
rsStub(Xlpf "ab7" "AB7" 0.35 0)
rsStub(Xlpf "ab8" "AB8" 0.35 0)
rsStub(Xlpf "fr0" "FR0" 0.35 0)
rsStub(Xlpf "fr1" "FR1" 0.35 0)
rsStub(Xlpf "fr2" "FR2" 0.35 0)
rsStub(Xlpf "fr3" "FR3" 0.35 0)
rsStub(Xlpf "fr4" "FR4" 0.35 0)
rsStub(Xlpf "fr5" "FR5" 0.35 0)
rsStub(Xlpf "fr6" "FR6" 0.35 0)
rsStub(Xlpf "fr7" "FR7" 0.35 0)
rsStub(Xlpf "fr8" "FR8" 0.35 0)
rsStub(Xlpf "fr9" "FR9" 0.35 0)
rsStub(Xlpf "fr10" "FR10" 0.35 0)
rsStub(Xlpf "fr11" "FR11" 0.35 0)
rsStub(Xlpf "fr12" "FR12" 0.35 0)
rsStub(Xlpf "fr13" "FR13" 0.35 0)
rsStub(Xlpf "fr14" "FR14" 0.35 0)
rsStub(Xlpf "fr15" "FR15" 0.35 0)
rsStub(Xlpf "fr16" "FR16" 0.35 0)
rsStub(Xlpf "fr17" "FR17" 0.35 0)
rsStub(Xlpf "fr18" "FR18" 0.35 0)
rsStub(Xlpf "fr19" "FR19" 0.35 0)
rsStub(Xlpf "fr20" "FR20" 0.35 0)
rsStub(Xlpf "fr21" "FR21" 0.35 0)
rsStub(Xlpf "fr22" "FR22" 0.35 0)
rsStub(Xlpf "fr23" "FR23" 0.35 0)
rsStub(Xlpf "fr24" "FR24" 0.35 0)
rsStub(Xlpf "fr25" "FR25" 0.35 0)

Xdacab = dbCreateInstByMasterName(cv "adpll_sch" "pll_dac9b" "symbol" "Xdacab" 12:-2 "R0")
rsProp(Xdacab "vmax" "0.5")
rsStub(Xdacab "out" "VC1" 0.35 0)
rsStub(Xdacab "code0" "AB0" -0.35 0)
rsStub(Xdacab "code1" "AB1" -0.35 0)
rsStub(Xdacab "code2" "AB2" -0.35 0)
rsStub(Xdacab "code3" "AB3" -0.35 0)
rsStub(Xdacab "code4" "AB4" -0.35 0)
rsStub(Xdacab "code5" "AB5" -0.35 0)
rsStub(Xdacab "code6" "AB6" -0.35 0)
rsStub(Xdacab "code7" "AB7" -0.35 0)
rsStub(Xdacab "code8" "AB8" -0.35 0)

Xdsmd = dbCreateInstByMasterName(cv "adpll_sch" "pll_dsm_dco" "symbol" "Xdsmd" 24:-2 "R0")
rsProp(Xdsmd "dsm_dco_mode" "0")
rsStub(Xdsmd "clk" "REF" -0.35 0)
rsStub(Xdsmd "fr0" "FR0" -0.35 0)
rsStub(Xdsmd "fr1" "FR1" -0.35 0)
rsStub(Xdsmd "fr2" "FR2" -0.35 0)
rsStub(Xdsmd "fr3" "FR3" -0.35 0)
rsStub(Xdsmd "fr4" "FR4" -0.35 0)
rsStub(Xdsmd "fr5" "FR5" -0.35 0)
rsStub(Xdsmd "fr6" "FR6" -0.35 0)
rsStub(Xdsmd "fr7" "FR7" -0.35 0)
rsStub(Xdsmd "fr8" "FR8" -0.35 0)
rsStub(Xdsmd "fr9" "FR9" -0.35 0)
rsStub(Xdsmd "fr10" "FR10" -0.35 0)
rsStub(Xdsmd "fr11" "FR11" -0.35 0)
rsStub(Xdsmd "fr12" "FR12" -0.35 0)
rsStub(Xdsmd "fr13" "FR13" -0.35 0)
rsStub(Xdsmd "fr14" "FR14" -0.35 0)
rsStub(Xdsmd "fr15" "FR15" -0.35 0)
rsStub(Xdsmd "fr16" "FR16" -0.35 0)
rsStub(Xdsmd "fr17" "FR17" -0.35 0)
rsStub(Xdsmd "fr18" "FR18" -0.35 0)
rsStub(Xdsmd "fr19" "FR19" -0.35 0)
rsStub(Xdsmd "fr20" "FR20" -0.35 0)
rsStub(Xdsmd "fr21" "FR21" -0.35 0)
rsStub(Xdsmd "fr22" "FR22" -0.35 0)
rsStub(Xdsmd "fr23" "FR23" -0.35 0)
rsStub(Xdsmd "fr24" "FR24" -0.35 0)
rsStub(Xdsmd "fr25" "FR25" -0.35 0)
rsStub(Xdsmd "f0" "FC0" 0.35 0)
rsStub(Xdsmd "f1" "FC1" 0.35 0)
rsStub(Xdsmd "f2" "FC2" 0.35 0)
rsStub(Xdsmd "f3" "FC3" 0.35 0)

Xdacfb = dbCreateInstByMasterName(cv "adpll_sch" "pll_dac9b" "symbol" "Xdacfb" 36:-2 "R0")
rsProp(Xdacfb "vmax" "0.5")
rsStub(Xdacfb "out" "VC2" 0.35 0)
rsStub(Xdacfb "code0" "FC0" -0.35 0)
rsStub(Xdacfb "code1" "FC1" -0.35 0)
rsStub(Xdacfb "code2" "FC2" -0.35 0)
rsStub(Xdacfb "code3" "FC3" -0.35 0)
rsStub(Xdacfb "code4" "VSS" -0.35 0)
rsStub(Xdacfb "code5" "VSS" -0.35 0)
rsStub(Xdacfb "code6" "VSS" -0.35 0)
rsStub(Xdacfb "code7" "VSS" -0.35 0)
rsStub(Xdacfb "code8" "VSS" -0.35 0)

Xcalk = dbCreateInstByMasterName(cv "adpll_sch" "pll_cal_kdtc" "symbol" "Xcalk" 48:-2 "R0")
rsStub(Xcalk "clk" "REF" -0.35 0)
rsStub(Xcalk "phe" "PHE" -0.35 0)
rsStub(Xcalk "q_err" "QERR" -0.35 0)
rsStub(Xcalk "dcomp" "DCOMP" -0.35 0)
rsStub(Xcalk "en" "ENP" -0.35 0)
rsStub(Xcalk "d0" "DT0" 0.35 0)
rsStub(Xcalk "d1" "DT1" 0.35 0)
rsStub(Xcalk "d2" "DT2" 0.35 0)
rsStub(Xcalk "d3" "DT3" 0.35 0)
rsStub(Xcalk "d4" "DT4" 0.35 0)
rsStub(Xcalk "d5" "DT5" 0.35 0)
rsStub(Xcalk "d6" "DT6" 0.35 0)
rsStub(Xcalk "d7" "DT7" 0.35 0)
rsStub(Xcalk "d8" "DT8" 0.35 0)
rsStub(Xcalk "d9" "DT9" 0.35 0)
rsStub(Xcalk "kdtc_dbg" "KDBG" 0.35 0)

Xcald = dbCreateInstByMasterName(cv "adpll_sch" "pll_cal_dcodcc" "symbol" "Xcald" 60:-2 "R0")
rsStub(Xcald "clk" "REF" -0.35 0)
rsStub(Xcald "phe" "PHE" -0.35 0)
rsStub(Xcald "sel" "SELF" -0.35 0)
rsStub(Xcald "en" "ENP" -0.35 0)
rsStub(Xcald "dcomp" "DCOMP" 0.35 0)
rsStub(Xcald "dcoef_dbg" "DDBG" 0.35 0)

Xdtc = dbCreateInstByMasterName(cv "adpll_sch" "dtc_10b_ss" "symbol" "Xdtc" 0:-24 "R0")
rsStub(Xdtc "CK_IN" "REF" -0.35 0)
rsStub(Xdtc "CK_OUT" "CKR" 0.35 0)
rsStub(Xdtc "VDD" "VDD" -0.35 0)
rsStub(Xdtc "VSS" "VSS" -0.35 0)
rsStub(Xdtc "CODE0" "DT0" -0.35 0)
rsStub(Xdtc "CODE1" "DT1" -0.35 0)
rsStub(Xdtc "CODE2" "DT2" -0.35 0)
rsStub(Xdtc "CODE3" "DT3" -0.35 0)
rsStub(Xdtc "CODE4" "DT4" -0.35 0)
rsStub(Xdtc "CODE5" "DT5" -0.35 0)
rsStub(Xdtc "CODE6" "DT6" -0.35 0)
rsStub(Xdtc "CODE7" "DT7" -0.35 0)
rsStub(Xdtc "CODE8" "DT8" -0.35 0)
rsStub(Xdtc "CODE9" "DT9" -0.35 0)

Xvco = dbCreateInstByMasterName(cv "adpll_sch" "vco_x_c_dac" "symbol" "Xvco" 12:-24 "R0")
rsStub(Xvco "VDD" "VDDC" -0.35 0)
rsStub(Xvco "VDDC" "VDDC" -0.35 0)
rsStub(Xvco "VSS" "VSS" -0.35 0)
rsStub(Xvco "OUTP" "OUTP" 0.35 0)
rsStub(Xvco "OUTN" "OUTN" 0.35 0)
rsStub(Xvco "VC1" "VC1" -0.35 0)
rsStub(Xvco "VC2" "VC2" -0.35 0)

Xldo = dbCreateInstByMasterName(cv "adpll_sch" "ldo_05" "symbol" "Xldo" 24:-24 "R0")
rsStub(Xldo "VDD" "VDD" -0.35 0)
rsStub(Xldo "VIN" "V1V" -0.35 0)
rsStub(Xldo "VBG" "VBG" -0.35 0)
rsStub(Xldo "VBL" "VBL" -0.35 0)
rsStub(Xldo "VOUT" "VDDC" 0.35 0)
rsStub(Xldo "VSS" "VSS" -0.35 0)

Rbuf = dbCreateInstByMasterName(cv "analogLib" "res" "symbol" "Rbuf" 36:-24 "R0")
rsProp(Rbuf "r" "1k")
rsStub(Rbuf "PLUS" "OUTP" 0 0.25)
rsStub(Rbuf "MINUS" "BUFFIN" 0 -0.25)

Minvb1_n = dbCreateInstByMasterName(cv "tsmcN12" "nch_svt_mac" "symbol" "Minvb1_n" 48:-26 "R0")
rsProp(Minvb1_n "fingers" "4") rsProp(Minvb1_n "nf" "4")
rsStub(Minvb1_n "D" "NBUF1" 0 0.25)
rsStub(Minvb1_n "G" "BUFFIN" -0.25 0)
rsStub(Minvb1_n "S" "VSS" 0 -0.25)
rsStub(Minvb1_n "B" "VSS" 0.25 0)

Minvb1_p = dbCreateInstByMasterName(cv "tsmcN12" "pch_svt_mac" "symbol" "Minvb1_p" 48:-22 "R0")
rsProp(Minvb1_p "fingers" "4") rsProp(Minvb1_p "nf" "4")
rsStub(Minvb1_p "D" "NBUF1" 0 -0.25)
rsStub(Minvb1_p "G" "BUFFIN" -0.25 0)
rsStub(Minvb1_p "S" "VDD" 0 0.25)
rsStub(Minvb1_p "B" "VDD" 0.25 0)

Minvb2_n = dbCreateInstByMasterName(cv "tsmcN12" "nch_svt_mac" "symbol" "Minvb2_n" 60:-26 "R0")
rsProp(Minvb2_n "fingers" "4") rsProp(Minvb2_n "nf" "4")
rsStub(Minvb2_n "D" "OUTPB" 0 0.25)
rsStub(Minvb2_n "G" "NBUF1" -0.25 0)
rsStub(Minvb2_n "S" "VSS" 0 -0.25)
rsStub(Minvb2_n "B" "VSS" 0.25 0)

Minvb2_p = dbCreateInstByMasterName(cv "tsmcN12" "pch_svt_mac" "symbol" "Minvb2_p" 60:-22 "R0")
rsProp(Minvb2_p "fingers" "4") rsProp(Minvb2_p "nf" "4")
rsStub(Minvb2_p "D" "OUTPB" 0 -0.25)
rsStub(Minvb2_p "G" "NBUF1" -0.25 0)
rsStub(Minvb2_p "S" "VDD" 0 0.25)
rsStub(Minvb2_p "B" "VDD" 0.25 0)

rsPinAt("REF" "input" -8.0 20.0)
rsPinAt("RSTN" "input" -8.0 18.0)
rsPinAt("RCOMP" "input" -8.0 16.0)
rsPinAt("VDD" "inputOutput" -8.0 14.0)
rsPinAt("V1V" "inputOutput" -8.0 12.0)
rsPinAt("VBG" "input" -8.0 10.0)
rsPinAt("VBL" "input" -8.0 8.0)
rsPinAt("VSS" "inputOutput" -8.0 6.0)
rsPinAt("OUTP" "output" -8.0 4.0)
rsPinAt("OUTN" "output" -8.0 2.0)

printf("TOP_BUILD_DONE instances=%d\n" length(cv~>instances))
