// pll_dtc_decoder_10b.va — 10-bit thermometer decoder (1023 outputs), generated
// code = round((kdtc*QE_sec + sel*vdcc + alt*rdcc)/Tres); thermometer = code + 511
`include "constants.vams"
`include "disciplines.vams"

module pll_dtc_decoder_10b(ckfb, kdtc, epsc, sel, alt, vdcc, rdcc,
    c0, c1, c2, c3, c4, c5, c6, c7, c8, c9, c10, c11, c12, c13, c14, c15,
    c16, c17, c18, c19, c20, c21, c22, c23, c24, c25, c26, c27, c28, c29, c30, c31,
    c32, c33, c34, c35, c36, c37, c38, c39, c40, c41, c42, c43, c44, c45, c46, c47,
    c48, c49, c50, c51, c52, c53, c54, c55, c56, c57, c58, c59, c60, c61, c62, c63,
    c64, c65, c66, c67, c68, c69, c70, c71, c72, c73, c74, c75, c76, c77, c78, c79,
    c80, c81, c82, c83, c84, c85, c86, c87, c88, c89, c90, c91, c92, c93, c94, c95,
    c96, c97, c98, c99, c100, c101, c102, c103, c104, c105, c106, c107, c108, c109, c110, c111,
    c112, c113, c114, c115, c116, c117, c118, c119, c120, c121, c122, c123, c124, c125, c126, c127,
    c128, c129, c130, c131, c132, c133, c134, c135, c136, c137, c138, c139, c140, c141, c142, c143,
    c144, c145, c146, c147, c148, c149, c150, c151, c152, c153, c154, c155, c156, c157, c158, c159,
    c160, c161, c162, c163, c164, c165, c166, c167, c168, c169, c170, c171, c172, c173, c174, c175,
    c176, c177, c178, c179, c180, c181, c182, c183, c184, c185, c186, c187, c188, c189, c190, c191,
    c192, c193, c194, c195, c196, c197, c198, c199, c200, c201, c202, c203, c204, c205, c206, c207,
    c208, c209, c210, c211, c212, c213, c214, c215, c216, c217, c218, c219, c220, c221, c222, c223,
    c224, c225, c226, c227, c228, c229, c230, c231, c232, c233, c234, c235, c236, c237, c238, c239,
    c240, c241, c242, c243, c244, c245, c246, c247, c248, c249, c250, c251, c252, c253, c254, c255,
    c256, c257, c258, c259, c260, c261, c262, c263, c264, c265, c266, c267, c268, c269, c270, c271,
    c272, c273, c274, c275, c276, c277, c278, c279, c280, c281, c282, c283, c284, c285, c286, c287,
    c288, c289, c290, c291, c292, c293, c294, c295, c296, c297, c298, c299, c300, c301, c302, c303,
    c304, c305, c306, c307, c308, c309, c310, c311, c312, c313, c314, c315, c316, c317, c318, c319,
    c320, c321, c322, c323, c324, c325, c326, c327, c328, c329, c330, c331, c332, c333, c334, c335,
    c336, c337, c338, c339, c340, c341, c342, c343, c344, c345, c346, c347, c348, c349, c350, c351,
    c352, c353, c354, c355, c356, c357, c358, c359, c360, c361, c362, c363, c364, c365, c366, c367,
    c368, c369, c370, c371, c372, c373, c374, c375, c376, c377, c378, c379, c380, c381, c382, c383,
    c384, c385, c386, c387, c388, c389, c390, c391, c392, c393, c394, c395, c396, c397, c398, c399,
    c400, c401, c402, c403, c404, c405, c406, c407, c408, c409, c410, c411, c412, c413, c414, c415,
    c416, c417, c418, c419, c420, c421, c422, c423, c424, c425, c426, c427, c428, c429, c430, c431,
    c432, c433, c434, c435, c436, c437, c438, c439, c440, c441, c442, c443, c444, c445, c446, c447,
    c448, c449, c450, c451, c452, c453, c454, c455, c456, c457, c458, c459, c460, c461, c462, c463,
    c464, c465, c466, c467, c468, c469, c470, c471, c472, c473, c474, c475, c476, c477, c478, c479,
    c480, c481, c482, c483, c484, c485, c486, c487, c488, c489, c490, c491, c492, c493, c494, c495,
    c496, c497, c498, c499, c500, c501, c502, c503, c504, c505, c506, c507, c508, c509, c510, c511,
    c512, c513, c514, c515, c516, c517, c518, c519, c520, c521, c522, c523, c524, c525, c526, c527,
    c528, c529, c530, c531, c532, c533, c534, c535, c536, c537, c538, c539, c540, c541, c542, c543,
    c544, c545, c546, c547, c548, c549, c550, c551, c552, c553, c554, c555, c556, c557, c558, c559,
    c560, c561, c562, c563, c564, c565, c566, c567, c568, c569, c570, c571, c572, c573, c574, c575,
    c576, c577, c578, c579, c580, c581, c582, c583, c584, c585, c586, c587, c588, c589, c590, c591,
    c592, c593, c594, c595, c596, c597, c598, c599, c600, c601, c602, c603, c604, c605, c606, c607,
    c608, c609, c610, c611, c612, c613, c614, c615, c616, c617, c618, c619, c620, c621, c622, c623,
    c624, c625, c626, c627, c628, c629, c630, c631, c632, c633, c634, c635, c636, c637, c638, c639,
    c640, c641, c642, c643, c644, c645, c646, c647, c648, c649, c650, c651, c652, c653, c654, c655,
    c656, c657, c658, c659, c660, c661, c662, c663, c664, c665, c666, c667, c668, c669, c670, c671,
    c672, c673, c674, c675, c676, c677, c678, c679, c680, c681, c682, c683, c684, c685, c686, c687,
    c688, c689, c690, c691, c692, c693, c694, c695, c696, c697, c698, c699, c700, c701, c702, c703,
    c704, c705, c706, c707, c708, c709, c710, c711, c712, c713, c714, c715, c716, c717, c718, c719,
    c720, c721, c722, c723, c724, c725, c726, c727, c728, c729, c730, c731, c732, c733, c734, c735,
    c736, c737, c738, c739, c740, c741, c742, c743, c744, c745, c746, c747, c748, c749, c750, c751,
    c752, c753, c754, c755, c756, c757, c758, c759, c760, c761, c762, c763, c764, c765, c766, c767,
    c768, c769, c770, c771, c772, c773, c774, c775, c776, c777, c778, c779, c780, c781, c782, c783,
    c784, c785, c786, c787, c788, c789, c790, c791, c792, c793, c794, c795, c796, c797, c798, c799,
    c800, c801, c802, c803, c804, c805, c806, c807, c808, c809, c810, c811, c812, c813, c814, c815,
    c816, c817, c818, c819, c820, c821, c822, c823, c824, c825, c826, c827, c828, c829, c830, c831,
    c832, c833, c834, c835, c836, c837, c838, c839, c840, c841, c842, c843, c844, c845, c846, c847,
    c848, c849, c850, c851, c852, c853, c854, c855, c856, c857, c858, c859, c860, c861, c862, c863,
    c864, c865, c866, c867, c868, c869, c870, c871, c872, c873, c874, c875, c876, c877, c878, c879,
    c880, c881, c882, c883, c884, c885, c886, c887, c888, c889, c890, c891, c892, c893, c894, c895,
    c896, c897, c898, c899, c900, c901, c902, c903, c904, c905, c906, c907, c908, c909, c910, c911,
    c912, c913, c914, c915, c916, c917, c918, c919, c920, c921, c922, c923, c924, c925, c926, c927,
    c928, c929, c930, c931, c932, c933, c934, c935, c936, c937, c938, c939, c940, c941, c942, c943,
    c944, c945, c946, c947, c948, c949, c950, c951, c952, c953, c954, c955, c956, c957, c958, c959,
    c960, c961, c962, c963, c964, c965, c966, c967, c968, c969, c970, c971, c972, c973, c974, c975,
    c976, c977, c978, c979, c980, c981, c982, c983, c984, c985, c986, c987, c988, c989, c990, c991,
    c992, c993, c994, c995, c996, c997, c998, c999, c1000, c1001, c1002, c1003, c1004, c1005, c1006, c1007,
    c1008, c1009, c1010, c1011, c1012, c1013, c1014, c1015, c1016, c1017, c1018, c1019, c1020, c1021, c1022);
inout ckfb, kdtc, epsc, sel, alt, vdcc, rdcc;
electrical ckfb, kdtc, epsc, sel, alt, vdcc, rdcc;
inout c0;
electrical c0;
inout c1;
electrical c1;
inout c2;
electrical c2;
inout c3;
electrical c3;
inout c4;
electrical c4;
inout c5;
electrical c5;
inout c6;
electrical c6;
inout c7;
electrical c7;
inout c8;
electrical c8;
inout c9;
electrical c9;
inout c10;
electrical c10;
inout c11;
electrical c11;
inout c12;
electrical c12;
inout c13;
electrical c13;
inout c14;
electrical c14;
inout c15;
electrical c15;
inout c16;
electrical c16;
inout c17;
electrical c17;
inout c18;
electrical c18;
inout c19;
electrical c19;
inout c20;
electrical c20;
inout c21;
electrical c21;
inout c22;
electrical c22;
inout c23;
electrical c23;
inout c24;
electrical c24;
inout c25;
electrical c25;
inout c26;
electrical c26;
inout c27;
electrical c27;
inout c28;
electrical c28;
inout c29;
electrical c29;
inout c30;
electrical c30;
inout c31;
electrical c31;
inout c32;
electrical c32;
inout c33;
electrical c33;
inout c34;
electrical c34;
inout c35;
electrical c35;
inout c36;
electrical c36;
inout c37;
electrical c37;
inout c38;
electrical c38;
inout c39;
electrical c39;
inout c40;
electrical c40;
inout c41;
electrical c41;
inout c42;
electrical c42;
inout c43;
electrical c43;
inout c44;
electrical c44;
inout c45;
electrical c45;
inout c46;
electrical c46;
inout c47;
electrical c47;
inout c48;
electrical c48;
inout c49;
electrical c49;
inout c50;
electrical c50;
inout c51;
electrical c51;
inout c52;
electrical c52;
inout c53;
electrical c53;
inout c54;
electrical c54;
inout c55;
electrical c55;
inout c56;
electrical c56;
inout c57;
electrical c57;
inout c58;
electrical c58;
inout c59;
electrical c59;
inout c60;
electrical c60;
inout c61;
electrical c61;
inout c62;
electrical c62;
inout c63;
electrical c63;
inout c64;
electrical c64;
inout c65;
electrical c65;
inout c66;
electrical c66;
inout c67;
electrical c67;
inout c68;
electrical c68;
inout c69;
electrical c69;
inout c70;
electrical c70;
inout c71;
electrical c71;
inout c72;
electrical c72;
inout c73;
electrical c73;
inout c74;
electrical c74;
inout c75;
electrical c75;
inout c76;
electrical c76;
inout c77;
electrical c77;
inout c78;
electrical c78;
inout c79;
electrical c79;
inout c80;
electrical c80;
inout c81;
electrical c81;
inout c82;
electrical c82;
inout c83;
electrical c83;
inout c84;
electrical c84;
inout c85;
electrical c85;
inout c86;
electrical c86;
inout c87;
electrical c87;
inout c88;
electrical c88;
inout c89;
electrical c89;
inout c90;
electrical c90;
inout c91;
electrical c91;
inout c92;
electrical c92;
inout c93;
electrical c93;
inout c94;
electrical c94;
inout c95;
electrical c95;
inout c96;
electrical c96;
inout c97;
electrical c97;
inout c98;
electrical c98;
inout c99;
electrical c99;
inout c100;
electrical c100;
inout c101;
electrical c101;
inout c102;
electrical c102;
inout c103;
electrical c103;
inout c104;
electrical c104;
inout c105;
electrical c105;
inout c106;
electrical c106;
inout c107;
electrical c107;
inout c108;
electrical c108;
inout c109;
electrical c109;
inout c110;
electrical c110;
inout c111;
electrical c111;
inout c112;
electrical c112;
inout c113;
electrical c113;
inout c114;
electrical c114;
inout c115;
electrical c115;
inout c116;
electrical c116;
inout c117;
electrical c117;
inout c118;
electrical c118;
inout c119;
electrical c119;
inout c120;
electrical c120;
inout c121;
electrical c121;
inout c122;
electrical c122;
inout c123;
electrical c123;
inout c124;
electrical c124;
inout c125;
electrical c125;
inout c126;
electrical c126;
inout c127;
electrical c127;
inout c128;
electrical c128;
inout c129;
electrical c129;
inout c130;
electrical c130;
inout c131;
electrical c131;
inout c132;
electrical c132;
inout c133;
electrical c133;
inout c134;
electrical c134;
inout c135;
electrical c135;
inout c136;
electrical c136;
inout c137;
electrical c137;
inout c138;
electrical c138;
inout c139;
electrical c139;
inout c140;
electrical c140;
inout c141;
electrical c141;
inout c142;
electrical c142;
inout c143;
electrical c143;
inout c144;
electrical c144;
inout c145;
electrical c145;
inout c146;
electrical c146;
inout c147;
electrical c147;
inout c148;
electrical c148;
inout c149;
electrical c149;
inout c150;
electrical c150;
inout c151;
electrical c151;
inout c152;
electrical c152;
inout c153;
electrical c153;
inout c154;
electrical c154;
inout c155;
electrical c155;
inout c156;
electrical c156;
inout c157;
electrical c157;
inout c158;
electrical c158;
inout c159;
electrical c159;
inout c160;
electrical c160;
inout c161;
electrical c161;
inout c162;
electrical c162;
inout c163;
electrical c163;
inout c164;
electrical c164;
inout c165;
electrical c165;
inout c166;
electrical c166;
inout c167;
electrical c167;
inout c168;
electrical c168;
inout c169;
electrical c169;
inout c170;
electrical c170;
inout c171;
electrical c171;
inout c172;
electrical c172;
inout c173;
electrical c173;
inout c174;
electrical c174;
inout c175;
electrical c175;
inout c176;
electrical c176;
inout c177;
electrical c177;
inout c178;
electrical c178;
inout c179;
electrical c179;
inout c180;
electrical c180;
inout c181;
electrical c181;
inout c182;
electrical c182;
inout c183;
electrical c183;
inout c184;
electrical c184;
inout c185;
electrical c185;
inout c186;
electrical c186;
inout c187;
electrical c187;
inout c188;
electrical c188;
inout c189;
electrical c189;
inout c190;
electrical c190;
inout c191;
electrical c191;
inout c192;
electrical c192;
inout c193;
electrical c193;
inout c194;
electrical c194;
inout c195;
electrical c195;
inout c196;
electrical c196;
inout c197;
electrical c197;
inout c198;
electrical c198;
inout c199;
electrical c199;
inout c200;
electrical c200;
inout c201;
electrical c201;
inout c202;
electrical c202;
inout c203;
electrical c203;
inout c204;
electrical c204;
inout c205;
electrical c205;
inout c206;
electrical c206;
inout c207;
electrical c207;
inout c208;
electrical c208;
inout c209;
electrical c209;
inout c210;
electrical c210;
inout c211;
electrical c211;
inout c212;
electrical c212;
inout c213;
electrical c213;
inout c214;
electrical c214;
inout c215;
electrical c215;
inout c216;
electrical c216;
inout c217;
electrical c217;
inout c218;
electrical c218;
inout c219;
electrical c219;
inout c220;
electrical c220;
inout c221;
electrical c221;
inout c222;
electrical c222;
inout c223;
electrical c223;
inout c224;
electrical c224;
inout c225;
electrical c225;
inout c226;
electrical c226;
inout c227;
electrical c227;
inout c228;
electrical c228;
inout c229;
electrical c229;
inout c230;
electrical c230;
inout c231;
electrical c231;
inout c232;
electrical c232;
inout c233;
electrical c233;
inout c234;
electrical c234;
inout c235;
electrical c235;
inout c236;
electrical c236;
inout c237;
electrical c237;
inout c238;
electrical c238;
inout c239;
electrical c239;
inout c240;
electrical c240;
inout c241;
electrical c241;
inout c242;
electrical c242;
inout c243;
electrical c243;
inout c244;
electrical c244;
inout c245;
electrical c245;
inout c246;
electrical c246;
inout c247;
electrical c247;
inout c248;
electrical c248;
inout c249;
electrical c249;
inout c250;
electrical c250;
inout c251;
electrical c251;
inout c252;
electrical c252;
inout c253;
electrical c253;
inout c254;
electrical c254;
inout c255;
electrical c255;
inout c256;
electrical c256;
inout c257;
electrical c257;
inout c258;
electrical c258;
inout c259;
electrical c259;
inout c260;
electrical c260;
inout c261;
electrical c261;
inout c262;
electrical c262;
inout c263;
electrical c263;
inout c264;
electrical c264;
inout c265;
electrical c265;
inout c266;
electrical c266;
inout c267;
electrical c267;
inout c268;
electrical c268;
inout c269;
electrical c269;
inout c270;
electrical c270;
inout c271;
electrical c271;
inout c272;
electrical c272;
inout c273;
electrical c273;
inout c274;
electrical c274;
inout c275;
electrical c275;
inout c276;
electrical c276;
inout c277;
electrical c277;
inout c278;
electrical c278;
inout c279;
electrical c279;
inout c280;
electrical c280;
inout c281;
electrical c281;
inout c282;
electrical c282;
inout c283;
electrical c283;
inout c284;
electrical c284;
inout c285;
electrical c285;
inout c286;
electrical c286;
inout c287;
electrical c287;
inout c288;
electrical c288;
inout c289;
electrical c289;
inout c290;
electrical c290;
inout c291;
electrical c291;
inout c292;
electrical c292;
inout c293;
electrical c293;
inout c294;
electrical c294;
inout c295;
electrical c295;
inout c296;
electrical c296;
inout c297;
electrical c297;
inout c298;
electrical c298;
inout c299;
electrical c299;
inout c300;
electrical c300;
inout c301;
electrical c301;
inout c302;
electrical c302;
inout c303;
electrical c303;
inout c304;
electrical c304;
inout c305;
electrical c305;
inout c306;
electrical c306;
inout c307;
electrical c307;
inout c308;
electrical c308;
inout c309;
electrical c309;
inout c310;
electrical c310;
inout c311;
electrical c311;
inout c312;
electrical c312;
inout c313;
electrical c313;
inout c314;
electrical c314;
inout c315;
electrical c315;
inout c316;
electrical c316;
inout c317;
electrical c317;
inout c318;
electrical c318;
inout c319;
electrical c319;
inout c320;
electrical c320;
inout c321;
electrical c321;
inout c322;
electrical c322;
inout c323;
electrical c323;
inout c324;
electrical c324;
inout c325;
electrical c325;
inout c326;
electrical c326;
inout c327;
electrical c327;
inout c328;
electrical c328;
inout c329;
electrical c329;
inout c330;
electrical c330;
inout c331;
electrical c331;
inout c332;
electrical c332;
inout c333;
electrical c333;
inout c334;
electrical c334;
inout c335;
electrical c335;
inout c336;
electrical c336;
inout c337;
electrical c337;
inout c338;
electrical c338;
inout c339;
electrical c339;
inout c340;
electrical c340;
inout c341;
electrical c341;
inout c342;
electrical c342;
inout c343;
electrical c343;
inout c344;
electrical c344;
inout c345;
electrical c345;
inout c346;
electrical c346;
inout c347;
electrical c347;
inout c348;
electrical c348;
inout c349;
electrical c349;
inout c350;
electrical c350;
inout c351;
electrical c351;
inout c352;
electrical c352;
inout c353;
electrical c353;
inout c354;
electrical c354;
inout c355;
electrical c355;
inout c356;
electrical c356;
inout c357;
electrical c357;
inout c358;
electrical c358;
inout c359;
electrical c359;
inout c360;
electrical c360;
inout c361;
electrical c361;
inout c362;
electrical c362;
inout c363;
electrical c363;
inout c364;
electrical c364;
inout c365;
electrical c365;
inout c366;
electrical c366;
inout c367;
electrical c367;
inout c368;
electrical c368;
inout c369;
electrical c369;
inout c370;
electrical c370;
inout c371;
electrical c371;
inout c372;
electrical c372;
inout c373;
electrical c373;
inout c374;
electrical c374;
inout c375;
electrical c375;
inout c376;
electrical c376;
inout c377;
electrical c377;
inout c378;
electrical c378;
inout c379;
electrical c379;
inout c380;
electrical c380;
inout c381;
electrical c381;
inout c382;
electrical c382;
inout c383;
electrical c383;
inout c384;
electrical c384;
inout c385;
electrical c385;
inout c386;
electrical c386;
inout c387;
electrical c387;
inout c388;
electrical c388;
inout c389;
electrical c389;
inout c390;
electrical c390;
inout c391;
electrical c391;
inout c392;
electrical c392;
inout c393;
electrical c393;
inout c394;
electrical c394;
inout c395;
electrical c395;
inout c396;
electrical c396;
inout c397;
electrical c397;
inout c398;
electrical c398;
inout c399;
electrical c399;
inout c400;
electrical c400;
inout c401;
electrical c401;
inout c402;
electrical c402;
inout c403;
electrical c403;
inout c404;
electrical c404;
inout c405;
electrical c405;
inout c406;
electrical c406;
inout c407;
electrical c407;
inout c408;
electrical c408;
inout c409;
electrical c409;
inout c410;
electrical c410;
inout c411;
electrical c411;
inout c412;
electrical c412;
inout c413;
electrical c413;
inout c414;
electrical c414;
inout c415;
electrical c415;
inout c416;
electrical c416;
inout c417;
electrical c417;
inout c418;
electrical c418;
inout c419;
electrical c419;
inout c420;
electrical c420;
inout c421;
electrical c421;
inout c422;
electrical c422;
inout c423;
electrical c423;
inout c424;
electrical c424;
inout c425;
electrical c425;
inout c426;
electrical c426;
inout c427;
electrical c427;
inout c428;
electrical c428;
inout c429;
electrical c429;
inout c430;
electrical c430;
inout c431;
electrical c431;
inout c432;
electrical c432;
inout c433;
electrical c433;
inout c434;
electrical c434;
inout c435;
electrical c435;
inout c436;
electrical c436;
inout c437;
electrical c437;
inout c438;
electrical c438;
inout c439;
electrical c439;
inout c440;
electrical c440;
inout c441;
electrical c441;
inout c442;
electrical c442;
inout c443;
electrical c443;
inout c444;
electrical c444;
inout c445;
electrical c445;
inout c446;
electrical c446;
inout c447;
electrical c447;
inout c448;
electrical c448;
inout c449;
electrical c449;
inout c450;
electrical c450;
inout c451;
electrical c451;
inout c452;
electrical c452;
inout c453;
electrical c453;
inout c454;
electrical c454;
inout c455;
electrical c455;
inout c456;
electrical c456;
inout c457;
electrical c457;
inout c458;
electrical c458;
inout c459;
electrical c459;
inout c460;
electrical c460;
inout c461;
electrical c461;
inout c462;
electrical c462;
inout c463;
electrical c463;
inout c464;
electrical c464;
inout c465;
electrical c465;
inout c466;
electrical c466;
inout c467;
electrical c467;
inout c468;
electrical c468;
inout c469;
electrical c469;
inout c470;
electrical c470;
inout c471;
electrical c471;
inout c472;
electrical c472;
inout c473;
electrical c473;
inout c474;
electrical c474;
inout c475;
electrical c475;
inout c476;
electrical c476;
inout c477;
electrical c477;
inout c478;
electrical c478;
inout c479;
electrical c479;
inout c480;
electrical c480;
inout c481;
electrical c481;
inout c482;
electrical c482;
inout c483;
electrical c483;
inout c484;
electrical c484;
inout c485;
electrical c485;
inout c486;
electrical c486;
inout c487;
electrical c487;
inout c488;
electrical c488;
inout c489;
electrical c489;
inout c490;
electrical c490;
inout c491;
electrical c491;
inout c492;
electrical c492;
inout c493;
electrical c493;
inout c494;
electrical c494;
inout c495;
electrical c495;
inout c496;
electrical c496;
inout c497;
electrical c497;
inout c498;
electrical c498;
inout c499;
electrical c499;
inout c500;
electrical c500;
inout c501;
electrical c501;
inout c502;
electrical c502;
inout c503;
electrical c503;
inout c504;
electrical c504;
inout c505;
electrical c505;
inout c506;
electrical c506;
inout c507;
electrical c507;
inout c508;
electrical c508;
inout c509;
electrical c509;
inout c510;
electrical c510;
inout c511;
electrical c511;
inout c512;
electrical c512;
inout c513;
electrical c513;
inout c514;
electrical c514;
inout c515;
electrical c515;
inout c516;
electrical c516;
inout c517;
electrical c517;
inout c518;
electrical c518;
inout c519;
electrical c519;
inout c520;
electrical c520;
inout c521;
electrical c521;
inout c522;
electrical c522;
inout c523;
electrical c523;
inout c524;
electrical c524;
inout c525;
electrical c525;
inout c526;
electrical c526;
inout c527;
electrical c527;
inout c528;
electrical c528;
inout c529;
electrical c529;
inout c530;
electrical c530;
inout c531;
electrical c531;
inout c532;
electrical c532;
inout c533;
electrical c533;
inout c534;
electrical c534;
inout c535;
electrical c535;
inout c536;
electrical c536;
inout c537;
electrical c537;
inout c538;
electrical c538;
inout c539;
electrical c539;
inout c540;
electrical c540;
inout c541;
electrical c541;
inout c542;
electrical c542;
inout c543;
electrical c543;
inout c544;
electrical c544;
inout c545;
electrical c545;
inout c546;
electrical c546;
inout c547;
electrical c547;
inout c548;
electrical c548;
inout c549;
electrical c549;
inout c550;
electrical c550;
inout c551;
electrical c551;
inout c552;
electrical c552;
inout c553;
electrical c553;
inout c554;
electrical c554;
inout c555;
electrical c555;
inout c556;
electrical c556;
inout c557;
electrical c557;
inout c558;
electrical c558;
inout c559;
electrical c559;
inout c560;
electrical c560;
inout c561;
electrical c561;
inout c562;
electrical c562;
inout c563;
electrical c563;
inout c564;
electrical c564;
inout c565;
electrical c565;
inout c566;
electrical c566;
inout c567;
electrical c567;
inout c568;
electrical c568;
inout c569;
electrical c569;
inout c570;
electrical c570;
inout c571;
electrical c571;
inout c572;
electrical c572;
inout c573;
electrical c573;
inout c574;
electrical c574;
inout c575;
electrical c575;
inout c576;
electrical c576;
inout c577;
electrical c577;
inout c578;
electrical c578;
inout c579;
electrical c579;
inout c580;
electrical c580;
inout c581;
electrical c581;
inout c582;
electrical c582;
inout c583;
electrical c583;
inout c584;
electrical c584;
inout c585;
electrical c585;
inout c586;
electrical c586;
inout c587;
electrical c587;
inout c588;
electrical c588;
inout c589;
electrical c589;
inout c590;
electrical c590;
inout c591;
electrical c591;
inout c592;
electrical c592;
inout c593;
electrical c593;
inout c594;
electrical c594;
inout c595;
electrical c595;
inout c596;
electrical c596;
inout c597;
electrical c597;
inout c598;
electrical c598;
inout c599;
electrical c599;
inout c600;
electrical c600;
inout c601;
electrical c601;
inout c602;
electrical c602;
inout c603;
electrical c603;
inout c604;
electrical c604;
inout c605;
electrical c605;
inout c606;
electrical c606;
inout c607;
electrical c607;
inout c608;
electrical c608;
inout c609;
electrical c609;
inout c610;
electrical c610;
inout c611;
electrical c611;
inout c612;
electrical c612;
inout c613;
electrical c613;
inout c614;
electrical c614;
inout c615;
electrical c615;
inout c616;
electrical c616;
inout c617;
electrical c617;
inout c618;
electrical c618;
inout c619;
electrical c619;
inout c620;
electrical c620;
inout c621;
electrical c621;
inout c622;
electrical c622;
inout c623;
electrical c623;
inout c624;
electrical c624;
inout c625;
electrical c625;
inout c626;
electrical c626;
inout c627;
electrical c627;
inout c628;
electrical c628;
inout c629;
electrical c629;
inout c630;
electrical c630;
inout c631;
electrical c631;
inout c632;
electrical c632;
inout c633;
electrical c633;
inout c634;
electrical c634;
inout c635;
electrical c635;
inout c636;
electrical c636;
inout c637;
electrical c637;
inout c638;
electrical c638;
inout c639;
electrical c639;
inout c640;
electrical c640;
inout c641;
electrical c641;
inout c642;
electrical c642;
inout c643;
electrical c643;
inout c644;
electrical c644;
inout c645;
electrical c645;
inout c646;
electrical c646;
inout c647;
electrical c647;
inout c648;
electrical c648;
inout c649;
electrical c649;
inout c650;
electrical c650;
inout c651;
electrical c651;
inout c652;
electrical c652;
inout c653;
electrical c653;
inout c654;
electrical c654;
inout c655;
electrical c655;
inout c656;
electrical c656;
inout c657;
electrical c657;
inout c658;
electrical c658;
inout c659;
electrical c659;
inout c660;
electrical c660;
inout c661;
electrical c661;
inout c662;
electrical c662;
inout c663;
electrical c663;
inout c664;
electrical c664;
inout c665;
electrical c665;
inout c666;
electrical c666;
inout c667;
electrical c667;
inout c668;
electrical c668;
inout c669;
electrical c669;
inout c670;
electrical c670;
inout c671;
electrical c671;
inout c672;
electrical c672;
inout c673;
electrical c673;
inout c674;
electrical c674;
inout c675;
electrical c675;
inout c676;
electrical c676;
inout c677;
electrical c677;
inout c678;
electrical c678;
inout c679;
electrical c679;
inout c680;
electrical c680;
inout c681;
electrical c681;
inout c682;
electrical c682;
inout c683;
electrical c683;
inout c684;
electrical c684;
inout c685;
electrical c685;
inout c686;
electrical c686;
inout c687;
electrical c687;
inout c688;
electrical c688;
inout c689;
electrical c689;
inout c690;
electrical c690;
inout c691;
electrical c691;
inout c692;
electrical c692;
inout c693;
electrical c693;
inout c694;
electrical c694;
inout c695;
electrical c695;
inout c696;
electrical c696;
inout c697;
electrical c697;
inout c698;
electrical c698;
inout c699;
electrical c699;
inout c700;
electrical c700;
inout c701;
electrical c701;
inout c702;
electrical c702;
inout c703;
electrical c703;
inout c704;
electrical c704;
inout c705;
electrical c705;
inout c706;
electrical c706;
inout c707;
electrical c707;
inout c708;
electrical c708;
inout c709;
electrical c709;
inout c710;
electrical c710;
inout c711;
electrical c711;
inout c712;
electrical c712;
inout c713;
electrical c713;
inout c714;
electrical c714;
inout c715;
electrical c715;
inout c716;
electrical c716;
inout c717;
electrical c717;
inout c718;
electrical c718;
inout c719;
electrical c719;
inout c720;
electrical c720;
inout c721;
electrical c721;
inout c722;
electrical c722;
inout c723;
electrical c723;
inout c724;
electrical c724;
inout c725;
electrical c725;
inout c726;
electrical c726;
inout c727;
electrical c727;
inout c728;
electrical c728;
inout c729;
electrical c729;
inout c730;
electrical c730;
inout c731;
electrical c731;
inout c732;
electrical c732;
inout c733;
electrical c733;
inout c734;
electrical c734;
inout c735;
electrical c735;
inout c736;
electrical c736;
inout c737;
electrical c737;
inout c738;
electrical c738;
inout c739;
electrical c739;
inout c740;
electrical c740;
inout c741;
electrical c741;
inout c742;
electrical c742;
inout c743;
electrical c743;
inout c744;
electrical c744;
inout c745;
electrical c745;
inout c746;
electrical c746;
inout c747;
electrical c747;
inout c748;
electrical c748;
inout c749;
electrical c749;
inout c750;
electrical c750;
inout c751;
electrical c751;
inout c752;
electrical c752;
inout c753;
electrical c753;
inout c754;
electrical c754;
inout c755;
electrical c755;
inout c756;
electrical c756;
inout c757;
electrical c757;
inout c758;
electrical c758;
inout c759;
electrical c759;
inout c760;
electrical c760;
inout c761;
electrical c761;
inout c762;
electrical c762;
inout c763;
electrical c763;
inout c764;
electrical c764;
inout c765;
electrical c765;
inout c766;
electrical c766;
inout c767;
electrical c767;
inout c768;
electrical c768;
inout c769;
electrical c769;
inout c770;
electrical c770;
inout c771;
electrical c771;
inout c772;
electrical c772;
inout c773;
electrical c773;
inout c774;
electrical c774;
inout c775;
electrical c775;
inout c776;
electrical c776;
inout c777;
electrical c777;
inout c778;
electrical c778;
inout c779;
electrical c779;
inout c780;
electrical c780;
inout c781;
electrical c781;
inout c782;
electrical c782;
inout c783;
electrical c783;
inout c784;
electrical c784;
inout c785;
electrical c785;
inout c786;
electrical c786;
inout c787;
electrical c787;
inout c788;
electrical c788;
inout c789;
electrical c789;
inout c790;
electrical c790;
inout c791;
electrical c791;
inout c792;
electrical c792;
inout c793;
electrical c793;
inout c794;
electrical c794;
inout c795;
electrical c795;
inout c796;
electrical c796;
inout c797;
electrical c797;
inout c798;
electrical c798;
inout c799;
electrical c799;
inout c800;
electrical c800;
inout c801;
electrical c801;
inout c802;
electrical c802;
inout c803;
electrical c803;
inout c804;
electrical c804;
inout c805;
electrical c805;
inout c806;
electrical c806;
inout c807;
electrical c807;
inout c808;
electrical c808;
inout c809;
electrical c809;
inout c810;
electrical c810;
inout c811;
electrical c811;
inout c812;
electrical c812;
inout c813;
electrical c813;
inout c814;
electrical c814;
inout c815;
electrical c815;
inout c816;
electrical c816;
inout c817;
electrical c817;
inout c818;
electrical c818;
inout c819;
electrical c819;
inout c820;
electrical c820;
inout c821;
electrical c821;
inout c822;
electrical c822;
inout c823;
electrical c823;
inout c824;
electrical c824;
inout c825;
electrical c825;
inout c826;
electrical c826;
inout c827;
electrical c827;
inout c828;
electrical c828;
inout c829;
electrical c829;
inout c830;
electrical c830;
inout c831;
electrical c831;
inout c832;
electrical c832;
inout c833;
electrical c833;
inout c834;
electrical c834;
inout c835;
electrical c835;
inout c836;
electrical c836;
inout c837;
electrical c837;
inout c838;
electrical c838;
inout c839;
electrical c839;
inout c840;
electrical c840;
inout c841;
electrical c841;
inout c842;
electrical c842;
inout c843;
electrical c843;
inout c844;
electrical c844;
inout c845;
electrical c845;
inout c846;
electrical c846;
inout c847;
electrical c847;
inout c848;
electrical c848;
inout c849;
electrical c849;
inout c850;
electrical c850;
inout c851;
electrical c851;
inout c852;
electrical c852;
inout c853;
electrical c853;
inout c854;
electrical c854;
inout c855;
electrical c855;
inout c856;
electrical c856;
inout c857;
electrical c857;
inout c858;
electrical c858;
inout c859;
electrical c859;
inout c860;
electrical c860;
inout c861;
electrical c861;
inout c862;
electrical c862;
inout c863;
electrical c863;
inout c864;
electrical c864;
inout c865;
electrical c865;
inout c866;
electrical c866;
inout c867;
electrical c867;
inout c868;
electrical c868;
inout c869;
electrical c869;
inout c870;
electrical c870;
inout c871;
electrical c871;
inout c872;
electrical c872;
inout c873;
electrical c873;
inout c874;
electrical c874;
inout c875;
electrical c875;
inout c876;
electrical c876;
inout c877;
electrical c877;
inout c878;
electrical c878;
inout c879;
electrical c879;
inout c880;
electrical c880;
inout c881;
electrical c881;
inout c882;
electrical c882;
inout c883;
electrical c883;
inout c884;
electrical c884;
inout c885;
electrical c885;
inout c886;
electrical c886;
inout c887;
electrical c887;
inout c888;
electrical c888;
inout c889;
electrical c889;
inout c890;
electrical c890;
inout c891;
electrical c891;
inout c892;
electrical c892;
inout c893;
electrical c893;
inout c894;
electrical c894;
inout c895;
electrical c895;
inout c896;
electrical c896;
inout c897;
electrical c897;
inout c898;
electrical c898;
inout c899;
electrical c899;
inout c900;
electrical c900;
inout c901;
electrical c901;
inout c902;
electrical c902;
inout c903;
electrical c903;
inout c904;
electrical c904;
inout c905;
electrical c905;
inout c906;
electrical c906;
inout c907;
electrical c907;
inout c908;
electrical c908;
inout c909;
electrical c909;
inout c910;
electrical c910;
inout c911;
electrical c911;
inout c912;
electrical c912;
inout c913;
electrical c913;
inout c914;
electrical c914;
inout c915;
electrical c915;
inout c916;
electrical c916;
inout c917;
electrical c917;
inout c918;
electrical c918;
inout c919;
electrical c919;
inout c920;
electrical c920;
inout c921;
electrical c921;
inout c922;
electrical c922;
inout c923;
electrical c923;
inout c924;
electrical c924;
inout c925;
electrical c925;
inout c926;
electrical c926;
inout c927;
electrical c927;
inout c928;
electrical c928;
inout c929;
electrical c929;
inout c930;
electrical c930;
inout c931;
electrical c931;
inout c932;
electrical c932;
inout c933;
electrical c933;
inout c934;
electrical c934;
inout c935;
electrical c935;
inout c936;
electrical c936;
inout c937;
electrical c937;
inout c938;
electrical c938;
inout c939;
electrical c939;
inout c940;
electrical c940;
inout c941;
electrical c941;
inout c942;
electrical c942;
inout c943;
electrical c943;
inout c944;
electrical c944;
inout c945;
electrical c945;
inout c946;
electrical c946;
inout c947;
electrical c947;
inout c948;
electrical c948;
inout c949;
electrical c949;
inout c950;
electrical c950;
inout c951;
electrical c951;
inout c952;
electrical c952;
inout c953;
electrical c953;
inout c954;
electrical c954;
inout c955;
electrical c955;
inout c956;
electrical c956;
inout c957;
electrical c957;
inout c958;
electrical c958;
inout c959;
electrical c959;
inout c960;
electrical c960;
inout c961;
electrical c961;
inout c962;
electrical c962;
inout c963;
electrical c963;
inout c964;
electrical c964;
inout c965;
electrical c965;
inout c966;
electrical c966;
inout c967;
electrical c967;
inout c968;
electrical c968;
inout c969;
electrical c969;
inout c970;
electrical c970;
inout c971;
electrical c971;
inout c972;
electrical c972;
inout c973;
electrical c973;
inout c974;
electrical c974;
inout c975;
electrical c975;
inout c976;
electrical c976;
inout c977;
electrical c977;
inout c978;
electrical c978;
inout c979;
electrical c979;
inout c980;
electrical c980;
inout c981;
electrical c981;
inout c982;
electrical c982;
inout c983;
electrical c983;
inout c984;
electrical c984;
inout c985;
electrical c985;
inout c986;
electrical c986;
inout c987;
electrical c987;
inout c988;
electrical c988;
inout c989;
electrical c989;
inout c990;
electrical c990;
inout c991;
electrical c991;
inout c992;
electrical c992;
inout c993;
electrical c993;
inout c994;
electrical c994;
inout c995;
electrical c995;
inout c996;
electrical c996;
inout c997;
electrical c997;
inout c998;
electrical c998;
inout c999;
electrical c999;
inout c1000;
electrical c1000;
inout c1001;
electrical c1001;
inout c1002;
electrical c1002;
inout c1003;
electrical c1003;
inout c1004;
electrical c1004;
inout c1005;
electrical c1005;
inout c1006;
electrical c1006;
inout c1007;
electrical c1007;
inout c1008;
electrical c1008;
inout c1009;
electrical c1009;
inout c1010;
electrical c1010;
inout c1011;
electrical c1011;
inout c1012;
electrical c1012;
inout c1013;
electrical c1013;
inout c1014;
electrical c1014;
inout c1015;
electrical c1015;
inout c1016;
electrical c1016;
inout c1017;
electrical c1017;
inout c1018;
electrical c1018;
inout c1019;
electrical c1019;
inout c1020;
electrical c1020;
inout c1021;
electrical c1021;
inout c1022;
electrical c1022;

parameter real fout = 6.2e9;
parameter real fref = 153.6e6;
parameter real frac2 = 0.729167;
parameter real Tres = 330e-15;
parameter real vth = 0.5;

real tdel, code_tot;
integer code;
analog begin
    @(initial_step) begin code = 0; code_tot = 511.0; end
    @(cross(V(ckfb) - vth, +1)) begin
        tdel = V(kdtc)*(V(epsc) - (0.5 - frac2))*(0.5/fout)
             + V(sel)*V(vdcc)*1e-12 + V(alt)*V(rdcc)*1e-12;
        code = (tdel >= 0.0) ? floor(tdel/Tres + 0.5) : ceil(tdel/Tres - 0.5);
        if (code > 511) code = 511;
        if (code < -511) code = -511;
        code_tot = code + 511.0;
    end
    V(c0) <+ transition((code_tot > 0) ? 0.8 : 0.0, 0.0, 50p, 50p);
    V(c1) <+ transition((code_tot > 1) ? 0.8 : 0.0, 0.0, 50p, 50p);
    V(c2) <+ transition((code_tot > 2) ? 0.8 : 0.0, 0.0, 50p, 50p);
    V(c3) <+ transition((code_tot > 3) ? 0.8 : 0.0, 0.0, 50p, 50p);
    V(c4) <+ transition((code_tot > 4) ? 0.8 : 0.0, 0.0, 50p, 50p);
    V(c5) <+ transition((code_tot > 5) ? 0.8 : 0.0, 0.0, 50p, 50p);
    V(c6) <+ transition((code_tot > 6) ? 0.8 : 0.0, 0.0, 50p, 50p);
    V(c7) <+ transition((code_tot > 7) ? 0.8 : 0.0, 0.0, 50p, 50p);
    V(c8) <+ transition((code_tot > 8) ? 0.8 : 0.0, 0.0, 50p, 50p);
    V(c9) <+ transition((code_tot > 9) ? 0.8 : 0.0, 0.0, 50p, 50p);
    V(c10) <+ transition((code_tot > 10) ? 0.8 : 0.0, 0.0, 50p, 50p);
    V(c11) <+ transition((code_tot > 11) ? 0.8 : 0.0, 0.0, 50p, 50p);
    V(c12) <+ transition((code_tot > 12) ? 0.8 : 0.0, 0.0, 50p, 50p);
    V(c13) <+ transition((code_tot > 13) ? 0.8 : 0.0, 0.0, 50p, 50p);
    V(c14) <+ transition((code_tot > 14) ? 0.8 : 0.0, 0.0, 50p, 50p);
    V(c15) <+ transition((code_tot > 15) ? 0.8 : 0.0, 0.0, 50p, 50p);
    V(c16) <+ transition((code_tot > 16) ? 0.8 : 0.0, 0.0, 50p, 50p);
    V(c17) <+ transition((code_tot > 17) ? 0.8 : 0.0, 0.0, 50p, 50p);
    V(c18) <+ transition((code_tot > 18) ? 0.8 : 0.0, 0.0, 50p, 50p);
    V(c19) <+ transition((code_tot > 19) ? 0.8 : 0.0, 0.0, 50p, 50p);
    V(c20) <+ transition((code_tot > 20) ? 0.8 : 0.0, 0.0, 50p, 50p);
    V(c21) <+ transition((code_tot > 21) ? 0.8 : 0.0, 0.0, 50p, 50p);
    V(c22) <+ transition((code_tot > 22) ? 0.8 : 0.0, 0.0, 50p, 50p);
    V(c23) <+ transition((code_tot > 23) ? 0.8 : 0.0, 0.0, 50p, 50p);
    V(c24) <+ transition((code_tot > 24) ? 0.8 : 0.0, 0.0, 50p, 50p);
    V(c25) <+ transition((code_tot > 25) ? 0.8 : 0.0, 0.0, 50p, 50p);
    V(c26) <+ transition((code_tot > 26) ? 0.8 : 0.0, 0.0, 50p, 50p);
    V(c27) <+ transition((code_tot > 27) ? 0.8 : 0.0, 0.0, 50p, 50p);
    V(c28) <+ transition((code_tot > 28) ? 0.8 : 0.0, 0.0, 50p, 50p);
    V(c29) <+ transition((code_tot > 29) ? 0.8 : 0.0, 0.0, 50p, 50p);
    V(c30) <+ transition((code_tot > 30) ? 0.8 : 0.0, 0.0, 50p, 50p);
    V(c31) <+ transition((code_tot > 31) ? 0.8 : 0.0, 0.0, 50p, 50p);
    V(c32) <+ transition((code_tot > 32) ? 0.8 : 0.0, 0.0, 50p, 50p);
    V(c33) <+ transition((code_tot > 33) ? 0.8 : 0.0, 0.0, 50p, 50p);
    V(c34) <+ transition((code_tot > 34) ? 0.8 : 0.0, 0.0, 50p, 50p);
    V(c35) <+ transition((code_tot > 35) ? 0.8 : 0.0, 0.0, 50p, 50p);
    V(c36) <+ transition((code_tot > 36) ? 0.8 : 0.0, 0.0, 50p, 50p);
    V(c37) <+ transition((code_tot > 37) ? 0.8 : 0.0, 0.0, 50p, 50p);
    V(c38) <+ transition((code_tot > 38) ? 0.8 : 0.0, 0.0, 50p, 50p);
    V(c39) <+ transition((code_tot > 39) ? 0.8 : 0.0, 0.0, 50p, 50p);
    V(c40) <+ transition((code_tot > 40) ? 0.8 : 0.0, 0.0, 50p, 50p);
    V(c41) <+ transition((code_tot > 41) ? 0.8 : 0.0, 0.0, 50p, 50p);
    V(c42) <+ transition((code_tot > 42) ? 0.8 : 0.0, 0.0, 50p, 50p);
    V(c43) <+ transition((code_tot > 43) ? 0.8 : 0.0, 0.0, 50p, 50p);
    V(c44) <+ transition((code_tot > 44) ? 0.8 : 0.0, 0.0, 50p, 50p);
    V(c45) <+ transition((code_tot > 45) ? 0.8 : 0.0, 0.0, 50p, 50p);
    V(c46) <+ transition((code_tot > 46) ? 0.8 : 0.0, 0.0, 50p, 50p);
    V(c47) <+ transition((code_tot > 47) ? 0.8 : 0.0, 0.0, 50p, 50p);
    V(c48) <+ transition((code_tot > 48) ? 0.8 : 0.0, 0.0, 50p, 50p);
    V(c49) <+ transition((code_tot > 49) ? 0.8 : 0.0, 0.0, 50p, 50p);
    V(c50) <+ transition((code_tot > 50) ? 0.8 : 0.0, 0.0, 50p, 50p);
    V(c51) <+ transition((code_tot > 51) ? 0.8 : 0.0, 0.0, 50p, 50p);
    V(c52) <+ transition((code_tot > 52) ? 0.8 : 0.0, 0.0, 50p, 50p);
    V(c53) <+ transition((code_tot > 53) ? 0.8 : 0.0, 0.0, 50p, 50p);
    V(c54) <+ transition((code_tot > 54) ? 0.8 : 0.0, 0.0, 50p, 50p);
    V(c55) <+ transition((code_tot > 55) ? 0.8 : 0.0, 0.0, 50p, 50p);
    V(c56) <+ transition((code_tot > 56) ? 0.8 : 0.0, 0.0, 50p, 50p);
    V(c57) <+ transition((code_tot > 57) ? 0.8 : 0.0, 0.0, 50p, 50p);
    V(c58) <+ transition((code_tot > 58) ? 0.8 : 0.0, 0.0, 50p, 50p);
    V(c59) <+ transition((code_tot > 59) ? 0.8 : 0.0, 0.0, 50p, 50p);
    V(c60) <+ transition((code_tot > 60) ? 0.8 : 0.0, 0.0, 50p, 50p);
    V(c61) <+ transition((code_tot > 61) ? 0.8 : 0.0, 0.0, 50p, 50p);
    V(c62) <+ transition((code_tot > 62) ? 0.8 : 0.0, 0.0, 50p, 50p);
    V(c63) <+ transition((code_tot > 63) ? 0.8 : 0.0, 0.0, 50p, 50p);
    V(c64) <+ transition((code_tot > 64) ? 0.8 : 0.0, 0.0, 50p, 50p);
    V(c65) <+ transition((code_tot > 65) ? 0.8 : 0.0, 0.0, 50p, 50p);
    V(c66) <+ transition((code_tot > 66) ? 0.8 : 0.0, 0.0, 50p, 50p);
    V(c67) <+ transition((code_tot > 67) ? 0.8 : 0.0, 0.0, 50p, 50p);
    V(c68) <+ transition((code_tot > 68) ? 0.8 : 0.0, 0.0, 50p, 50p);
    V(c69) <+ transition((code_tot > 69) ? 0.8 : 0.0, 0.0, 50p, 50p);
    V(c70) <+ transition((code_tot > 70) ? 0.8 : 0.0, 0.0, 50p, 50p);
    V(c71) <+ transition((code_tot > 71) ? 0.8 : 0.0, 0.0, 50p, 50p);
    V(c72) <+ transition((code_tot > 72) ? 0.8 : 0.0, 0.0, 50p, 50p);
    V(c73) <+ transition((code_tot > 73) ? 0.8 : 0.0, 0.0, 50p, 50p);
    V(c74) <+ transition((code_tot > 74) ? 0.8 : 0.0, 0.0, 50p, 50p);
    V(c75) <+ transition((code_tot > 75) ? 0.8 : 0.0, 0.0, 50p, 50p);
    V(c76) <+ transition((code_tot > 76) ? 0.8 : 0.0, 0.0, 50p, 50p);
    V(c77) <+ transition((code_tot > 77) ? 0.8 : 0.0, 0.0, 50p, 50p);
    V(c78) <+ transition((code_tot > 78) ? 0.8 : 0.0, 0.0, 50p, 50p);
    V(c79) <+ transition((code_tot > 79) ? 0.8 : 0.0, 0.0, 50p, 50p);
    V(c80) <+ transition((code_tot > 80) ? 0.8 : 0.0, 0.0, 50p, 50p);
    V(c81) <+ transition((code_tot > 81) ? 0.8 : 0.0, 0.0, 50p, 50p);
    V(c82) <+ transition((code_tot > 82) ? 0.8 : 0.0, 0.0, 50p, 50p);
    V(c83) <+ transition((code_tot > 83) ? 0.8 : 0.0, 0.0, 50p, 50p);
    V(c84) <+ transition((code_tot > 84) ? 0.8 : 0.0, 0.0, 50p, 50p);
    V(c85) <+ transition((code_tot > 85) ? 0.8 : 0.0, 0.0, 50p, 50p);
    V(c86) <+ transition((code_tot > 86) ? 0.8 : 0.0, 0.0, 50p, 50p);
    V(c87) <+ transition((code_tot > 87) ? 0.8 : 0.0, 0.0, 50p, 50p);
    V(c88) <+ transition((code_tot > 88) ? 0.8 : 0.0, 0.0, 50p, 50p);
    V(c89) <+ transition((code_tot > 89) ? 0.8 : 0.0, 0.0, 50p, 50p);
    V(c90) <+ transition((code_tot > 90) ? 0.8 : 0.0, 0.0, 50p, 50p);
    V(c91) <+ transition((code_tot > 91) ? 0.8 : 0.0, 0.0, 50p, 50p);
    V(c92) <+ transition((code_tot > 92) ? 0.8 : 0.0, 0.0, 50p, 50p);
    V(c93) <+ transition((code_tot > 93) ? 0.8 : 0.0, 0.0, 50p, 50p);
    V(c94) <+ transition((code_tot > 94) ? 0.8 : 0.0, 0.0, 50p, 50p);
    V(c95) <+ transition((code_tot > 95) ? 0.8 : 0.0, 0.0, 50p, 50p);
    V(c96) <+ transition((code_tot > 96) ? 0.8 : 0.0, 0.0, 50p, 50p);
    V(c97) <+ transition((code_tot > 97) ? 0.8 : 0.0, 0.0, 50p, 50p);
    V(c98) <+ transition((code_tot > 98) ? 0.8 : 0.0, 0.0, 50p, 50p);
    V(c99) <+ transition((code_tot > 99) ? 0.8 : 0.0, 0.0, 50p, 50p);
    V(c100) <+ transition((code_tot > 100) ? 0.8 : 0.0, 0.0, 50p, 50p);
    V(c101) <+ transition((code_tot > 101) ? 0.8 : 0.0, 0.0, 50p, 50p);
    V(c102) <+ transition((code_tot > 102) ? 0.8 : 0.0, 0.0, 50p, 50p);
    V(c103) <+ transition((code_tot > 103) ? 0.8 : 0.0, 0.0, 50p, 50p);
    V(c104) <+ transition((code_tot > 104) ? 0.8 : 0.0, 0.0, 50p, 50p);
    V(c105) <+ transition((code_tot > 105) ? 0.8 : 0.0, 0.0, 50p, 50p);
    V(c106) <+ transition((code_tot > 106) ? 0.8 : 0.0, 0.0, 50p, 50p);
    V(c107) <+ transition((code_tot > 107) ? 0.8 : 0.0, 0.0, 50p, 50p);
    V(c108) <+ transition((code_tot > 108) ? 0.8 : 0.0, 0.0, 50p, 50p);
    V(c109) <+ transition((code_tot > 109) ? 0.8 : 0.0, 0.0, 50p, 50p);
    V(c110) <+ transition((code_tot > 110) ? 0.8 : 0.0, 0.0, 50p, 50p);
    V(c111) <+ transition((code_tot > 111) ? 0.8 : 0.0, 0.0, 50p, 50p);
    V(c112) <+ transition((code_tot > 112) ? 0.8 : 0.0, 0.0, 50p, 50p);
    V(c113) <+ transition((code_tot > 113) ? 0.8 : 0.0, 0.0, 50p, 50p);
    V(c114) <+ transition((code_tot > 114) ? 0.8 : 0.0, 0.0, 50p, 50p);
    V(c115) <+ transition((code_tot > 115) ? 0.8 : 0.0, 0.0, 50p, 50p);
    V(c116) <+ transition((code_tot > 116) ? 0.8 : 0.0, 0.0, 50p, 50p);
    V(c117) <+ transition((code_tot > 117) ? 0.8 : 0.0, 0.0, 50p, 50p);
    V(c118) <+ transition((code_tot > 118) ? 0.8 : 0.0, 0.0, 50p, 50p);
    V(c119) <+ transition((code_tot > 119) ? 0.8 : 0.0, 0.0, 50p, 50p);
    V(c120) <+ transition((code_tot > 120) ? 0.8 : 0.0, 0.0, 50p, 50p);
    V(c121) <+ transition((code_tot > 121) ? 0.8 : 0.0, 0.0, 50p, 50p);
    V(c122) <+ transition((code_tot > 122) ? 0.8 : 0.0, 0.0, 50p, 50p);
    V(c123) <+ transition((code_tot > 123) ? 0.8 : 0.0, 0.0, 50p, 50p);
    V(c124) <+ transition((code_tot > 124) ? 0.8 : 0.0, 0.0, 50p, 50p);
    V(c125) <+ transition((code_tot > 125) ? 0.8 : 0.0, 0.0, 50p, 50p);
    V(c126) <+ transition((code_tot > 126) ? 0.8 : 0.0, 0.0, 50p, 50p);
    V(c127) <+ transition((code_tot > 127) ? 0.8 : 0.0, 0.0, 50p, 50p);
    V(c128) <+ transition((code_tot > 128) ? 0.8 : 0.0, 0.0, 50p, 50p);
    V(c129) <+ transition((code_tot > 129) ? 0.8 : 0.0, 0.0, 50p, 50p);
    V(c130) <+ transition((code_tot > 130) ? 0.8 : 0.0, 0.0, 50p, 50p);
    V(c131) <+ transition((code_tot > 131) ? 0.8 : 0.0, 0.0, 50p, 50p);
    V(c132) <+ transition((code_tot > 132) ? 0.8 : 0.0, 0.0, 50p, 50p);
    V(c133) <+ transition((code_tot > 133) ? 0.8 : 0.0, 0.0, 50p, 50p);
    V(c134) <+ transition((code_tot > 134) ? 0.8 : 0.0, 0.0, 50p, 50p);
    V(c135) <+ transition((code_tot > 135) ? 0.8 : 0.0, 0.0, 50p, 50p);
    V(c136) <+ transition((code_tot > 136) ? 0.8 : 0.0, 0.0, 50p, 50p);
    V(c137) <+ transition((code_tot > 137) ? 0.8 : 0.0, 0.0, 50p, 50p);
    V(c138) <+ transition((code_tot > 138) ? 0.8 : 0.0, 0.0, 50p, 50p);
    V(c139) <+ transition((code_tot > 139) ? 0.8 : 0.0, 0.0, 50p, 50p);
    V(c140) <+ transition((code_tot > 140) ? 0.8 : 0.0, 0.0, 50p, 50p);
    V(c141) <+ transition((code_tot > 141) ? 0.8 : 0.0, 0.0, 50p, 50p);
    V(c142) <+ transition((code_tot > 142) ? 0.8 : 0.0, 0.0, 50p, 50p);
    V(c143) <+ transition((code_tot > 143) ? 0.8 : 0.0, 0.0, 50p, 50p);
    V(c144) <+ transition((code_tot > 144) ? 0.8 : 0.0, 0.0, 50p, 50p);
    V(c145) <+ transition((code_tot > 145) ? 0.8 : 0.0, 0.0, 50p, 50p);
    V(c146) <+ transition((code_tot > 146) ? 0.8 : 0.0, 0.0, 50p, 50p);
    V(c147) <+ transition((code_tot > 147) ? 0.8 : 0.0, 0.0, 50p, 50p);
    V(c148) <+ transition((code_tot > 148) ? 0.8 : 0.0, 0.0, 50p, 50p);
    V(c149) <+ transition((code_tot > 149) ? 0.8 : 0.0, 0.0, 50p, 50p);
    V(c150) <+ transition((code_tot > 150) ? 0.8 : 0.0, 0.0, 50p, 50p);
    V(c151) <+ transition((code_tot > 151) ? 0.8 : 0.0, 0.0, 50p, 50p);
    V(c152) <+ transition((code_tot > 152) ? 0.8 : 0.0, 0.0, 50p, 50p);
    V(c153) <+ transition((code_tot > 153) ? 0.8 : 0.0, 0.0, 50p, 50p);
    V(c154) <+ transition((code_tot > 154) ? 0.8 : 0.0, 0.0, 50p, 50p);
    V(c155) <+ transition((code_tot > 155) ? 0.8 : 0.0, 0.0, 50p, 50p);
    V(c156) <+ transition((code_tot > 156) ? 0.8 : 0.0, 0.0, 50p, 50p);
    V(c157) <+ transition((code_tot > 157) ? 0.8 : 0.0, 0.0, 50p, 50p);
    V(c158) <+ transition((code_tot > 158) ? 0.8 : 0.0, 0.0, 50p, 50p);
    V(c159) <+ transition((code_tot > 159) ? 0.8 : 0.0, 0.0, 50p, 50p);
    V(c160) <+ transition((code_tot > 160) ? 0.8 : 0.0, 0.0, 50p, 50p);
    V(c161) <+ transition((code_tot > 161) ? 0.8 : 0.0, 0.0, 50p, 50p);
    V(c162) <+ transition((code_tot > 162) ? 0.8 : 0.0, 0.0, 50p, 50p);
    V(c163) <+ transition((code_tot > 163) ? 0.8 : 0.0, 0.0, 50p, 50p);
    V(c164) <+ transition((code_tot > 164) ? 0.8 : 0.0, 0.0, 50p, 50p);
    V(c165) <+ transition((code_tot > 165) ? 0.8 : 0.0, 0.0, 50p, 50p);
    V(c166) <+ transition((code_tot > 166) ? 0.8 : 0.0, 0.0, 50p, 50p);
    V(c167) <+ transition((code_tot > 167) ? 0.8 : 0.0, 0.0, 50p, 50p);
    V(c168) <+ transition((code_tot > 168) ? 0.8 : 0.0, 0.0, 50p, 50p);
    V(c169) <+ transition((code_tot > 169) ? 0.8 : 0.0, 0.0, 50p, 50p);
    V(c170) <+ transition((code_tot > 170) ? 0.8 : 0.0, 0.0, 50p, 50p);
    V(c171) <+ transition((code_tot > 171) ? 0.8 : 0.0, 0.0, 50p, 50p);
    V(c172) <+ transition((code_tot > 172) ? 0.8 : 0.0, 0.0, 50p, 50p);
    V(c173) <+ transition((code_tot > 173) ? 0.8 : 0.0, 0.0, 50p, 50p);
    V(c174) <+ transition((code_tot > 174) ? 0.8 : 0.0, 0.0, 50p, 50p);
    V(c175) <+ transition((code_tot > 175) ? 0.8 : 0.0, 0.0, 50p, 50p);
    V(c176) <+ transition((code_tot > 176) ? 0.8 : 0.0, 0.0, 50p, 50p);
    V(c177) <+ transition((code_tot > 177) ? 0.8 : 0.0, 0.0, 50p, 50p);
    V(c178) <+ transition((code_tot > 178) ? 0.8 : 0.0, 0.0, 50p, 50p);
    V(c179) <+ transition((code_tot > 179) ? 0.8 : 0.0, 0.0, 50p, 50p);
    V(c180) <+ transition((code_tot > 180) ? 0.8 : 0.0, 0.0, 50p, 50p);
    V(c181) <+ transition((code_tot > 181) ? 0.8 : 0.0, 0.0, 50p, 50p);
    V(c182) <+ transition((code_tot > 182) ? 0.8 : 0.0, 0.0, 50p, 50p);
    V(c183) <+ transition((code_tot > 183) ? 0.8 : 0.0, 0.0, 50p, 50p);
    V(c184) <+ transition((code_tot > 184) ? 0.8 : 0.0, 0.0, 50p, 50p);
    V(c185) <+ transition((code_tot > 185) ? 0.8 : 0.0, 0.0, 50p, 50p);
    V(c186) <+ transition((code_tot > 186) ? 0.8 : 0.0, 0.0, 50p, 50p);
    V(c187) <+ transition((code_tot > 187) ? 0.8 : 0.0, 0.0, 50p, 50p);
    V(c188) <+ transition((code_tot > 188) ? 0.8 : 0.0, 0.0, 50p, 50p);
    V(c189) <+ transition((code_tot > 189) ? 0.8 : 0.0, 0.0, 50p, 50p);
    V(c190) <+ transition((code_tot > 190) ? 0.8 : 0.0, 0.0, 50p, 50p);
    V(c191) <+ transition((code_tot > 191) ? 0.8 : 0.0, 0.0, 50p, 50p);
    V(c192) <+ transition((code_tot > 192) ? 0.8 : 0.0, 0.0, 50p, 50p);
    V(c193) <+ transition((code_tot > 193) ? 0.8 : 0.0, 0.0, 50p, 50p);
    V(c194) <+ transition((code_tot > 194) ? 0.8 : 0.0, 0.0, 50p, 50p);
    V(c195) <+ transition((code_tot > 195) ? 0.8 : 0.0, 0.0, 50p, 50p);
    V(c196) <+ transition((code_tot > 196) ? 0.8 : 0.0, 0.0, 50p, 50p);
    V(c197) <+ transition((code_tot > 197) ? 0.8 : 0.0, 0.0, 50p, 50p);
    V(c198) <+ transition((code_tot > 198) ? 0.8 : 0.0, 0.0, 50p, 50p);
    V(c199) <+ transition((code_tot > 199) ? 0.8 : 0.0, 0.0, 50p, 50p);
    V(c200) <+ transition((code_tot > 200) ? 0.8 : 0.0, 0.0, 50p, 50p);
    V(c201) <+ transition((code_tot > 201) ? 0.8 : 0.0, 0.0, 50p, 50p);
    V(c202) <+ transition((code_tot > 202) ? 0.8 : 0.0, 0.0, 50p, 50p);
    V(c203) <+ transition((code_tot > 203) ? 0.8 : 0.0, 0.0, 50p, 50p);
    V(c204) <+ transition((code_tot > 204) ? 0.8 : 0.0, 0.0, 50p, 50p);
    V(c205) <+ transition((code_tot > 205) ? 0.8 : 0.0, 0.0, 50p, 50p);
    V(c206) <+ transition((code_tot > 206) ? 0.8 : 0.0, 0.0, 50p, 50p);
    V(c207) <+ transition((code_tot > 207) ? 0.8 : 0.0, 0.0, 50p, 50p);
    V(c208) <+ transition((code_tot > 208) ? 0.8 : 0.0, 0.0, 50p, 50p);
    V(c209) <+ transition((code_tot > 209) ? 0.8 : 0.0, 0.0, 50p, 50p);
    V(c210) <+ transition((code_tot > 210) ? 0.8 : 0.0, 0.0, 50p, 50p);
    V(c211) <+ transition((code_tot > 211) ? 0.8 : 0.0, 0.0, 50p, 50p);
    V(c212) <+ transition((code_tot > 212) ? 0.8 : 0.0, 0.0, 50p, 50p);
    V(c213) <+ transition((code_tot > 213) ? 0.8 : 0.0, 0.0, 50p, 50p);
    V(c214) <+ transition((code_tot > 214) ? 0.8 : 0.0, 0.0, 50p, 50p);
    V(c215) <+ transition((code_tot > 215) ? 0.8 : 0.0, 0.0, 50p, 50p);
    V(c216) <+ transition((code_tot > 216) ? 0.8 : 0.0, 0.0, 50p, 50p);
    V(c217) <+ transition((code_tot > 217) ? 0.8 : 0.0, 0.0, 50p, 50p);
    V(c218) <+ transition((code_tot > 218) ? 0.8 : 0.0, 0.0, 50p, 50p);
    V(c219) <+ transition((code_tot > 219) ? 0.8 : 0.0, 0.0, 50p, 50p);
    V(c220) <+ transition((code_tot > 220) ? 0.8 : 0.0, 0.0, 50p, 50p);
    V(c221) <+ transition((code_tot > 221) ? 0.8 : 0.0, 0.0, 50p, 50p);
    V(c222) <+ transition((code_tot > 222) ? 0.8 : 0.0, 0.0, 50p, 50p);
    V(c223) <+ transition((code_tot > 223) ? 0.8 : 0.0, 0.0, 50p, 50p);
    V(c224) <+ transition((code_tot > 224) ? 0.8 : 0.0, 0.0, 50p, 50p);
    V(c225) <+ transition((code_tot > 225) ? 0.8 : 0.0, 0.0, 50p, 50p);
    V(c226) <+ transition((code_tot > 226) ? 0.8 : 0.0, 0.0, 50p, 50p);
    V(c227) <+ transition((code_tot > 227) ? 0.8 : 0.0, 0.0, 50p, 50p);
    V(c228) <+ transition((code_tot > 228) ? 0.8 : 0.0, 0.0, 50p, 50p);
    V(c229) <+ transition((code_tot > 229) ? 0.8 : 0.0, 0.0, 50p, 50p);
    V(c230) <+ transition((code_tot > 230) ? 0.8 : 0.0, 0.0, 50p, 50p);
    V(c231) <+ transition((code_tot > 231) ? 0.8 : 0.0, 0.0, 50p, 50p);
    V(c232) <+ transition((code_tot > 232) ? 0.8 : 0.0, 0.0, 50p, 50p);
    V(c233) <+ transition((code_tot > 233) ? 0.8 : 0.0, 0.0, 50p, 50p);
    V(c234) <+ transition((code_tot > 234) ? 0.8 : 0.0, 0.0, 50p, 50p);
    V(c235) <+ transition((code_tot > 235) ? 0.8 : 0.0, 0.0, 50p, 50p);
    V(c236) <+ transition((code_tot > 236) ? 0.8 : 0.0, 0.0, 50p, 50p);
    V(c237) <+ transition((code_tot > 237) ? 0.8 : 0.0, 0.0, 50p, 50p);
    V(c238) <+ transition((code_tot > 238) ? 0.8 : 0.0, 0.0, 50p, 50p);
    V(c239) <+ transition((code_tot > 239) ? 0.8 : 0.0, 0.0, 50p, 50p);
    V(c240) <+ transition((code_tot > 240) ? 0.8 : 0.0, 0.0, 50p, 50p);
    V(c241) <+ transition((code_tot > 241) ? 0.8 : 0.0, 0.0, 50p, 50p);
    V(c242) <+ transition((code_tot > 242) ? 0.8 : 0.0, 0.0, 50p, 50p);
    V(c243) <+ transition((code_tot > 243) ? 0.8 : 0.0, 0.0, 50p, 50p);
    V(c244) <+ transition((code_tot > 244) ? 0.8 : 0.0, 0.0, 50p, 50p);
    V(c245) <+ transition((code_tot > 245) ? 0.8 : 0.0, 0.0, 50p, 50p);
    V(c246) <+ transition((code_tot > 246) ? 0.8 : 0.0, 0.0, 50p, 50p);
    V(c247) <+ transition((code_tot > 247) ? 0.8 : 0.0, 0.0, 50p, 50p);
    V(c248) <+ transition((code_tot > 248) ? 0.8 : 0.0, 0.0, 50p, 50p);
    V(c249) <+ transition((code_tot > 249) ? 0.8 : 0.0, 0.0, 50p, 50p);
    V(c250) <+ transition((code_tot > 250) ? 0.8 : 0.0, 0.0, 50p, 50p);
    V(c251) <+ transition((code_tot > 251) ? 0.8 : 0.0, 0.0, 50p, 50p);
    V(c252) <+ transition((code_tot > 252) ? 0.8 : 0.0, 0.0, 50p, 50p);
    V(c253) <+ transition((code_tot > 253) ? 0.8 : 0.0, 0.0, 50p, 50p);
    V(c254) <+ transition((code_tot > 254) ? 0.8 : 0.0, 0.0, 50p, 50p);
    V(c255) <+ transition((code_tot > 255) ? 0.8 : 0.0, 0.0, 50p, 50p);
    V(c256) <+ transition((code_tot > 256) ? 0.8 : 0.0, 0.0, 50p, 50p);
    V(c257) <+ transition((code_tot > 257) ? 0.8 : 0.0, 0.0, 50p, 50p);
    V(c258) <+ transition((code_tot > 258) ? 0.8 : 0.0, 0.0, 50p, 50p);
    V(c259) <+ transition((code_tot > 259) ? 0.8 : 0.0, 0.0, 50p, 50p);
    V(c260) <+ transition((code_tot > 260) ? 0.8 : 0.0, 0.0, 50p, 50p);
    V(c261) <+ transition((code_tot > 261) ? 0.8 : 0.0, 0.0, 50p, 50p);
    V(c262) <+ transition((code_tot > 262) ? 0.8 : 0.0, 0.0, 50p, 50p);
    V(c263) <+ transition((code_tot > 263) ? 0.8 : 0.0, 0.0, 50p, 50p);
    V(c264) <+ transition((code_tot > 264) ? 0.8 : 0.0, 0.0, 50p, 50p);
    V(c265) <+ transition((code_tot > 265) ? 0.8 : 0.0, 0.0, 50p, 50p);
    V(c266) <+ transition((code_tot > 266) ? 0.8 : 0.0, 0.0, 50p, 50p);
    V(c267) <+ transition((code_tot > 267) ? 0.8 : 0.0, 0.0, 50p, 50p);
    V(c268) <+ transition((code_tot > 268) ? 0.8 : 0.0, 0.0, 50p, 50p);
    V(c269) <+ transition((code_tot > 269) ? 0.8 : 0.0, 0.0, 50p, 50p);
    V(c270) <+ transition((code_tot > 270) ? 0.8 : 0.0, 0.0, 50p, 50p);
    V(c271) <+ transition((code_tot > 271) ? 0.8 : 0.0, 0.0, 50p, 50p);
    V(c272) <+ transition((code_tot > 272) ? 0.8 : 0.0, 0.0, 50p, 50p);
    V(c273) <+ transition((code_tot > 273) ? 0.8 : 0.0, 0.0, 50p, 50p);
    V(c274) <+ transition((code_tot > 274) ? 0.8 : 0.0, 0.0, 50p, 50p);
    V(c275) <+ transition((code_tot > 275) ? 0.8 : 0.0, 0.0, 50p, 50p);
    V(c276) <+ transition((code_tot > 276) ? 0.8 : 0.0, 0.0, 50p, 50p);
    V(c277) <+ transition((code_tot > 277) ? 0.8 : 0.0, 0.0, 50p, 50p);
    V(c278) <+ transition((code_tot > 278) ? 0.8 : 0.0, 0.0, 50p, 50p);
    V(c279) <+ transition((code_tot > 279) ? 0.8 : 0.0, 0.0, 50p, 50p);
    V(c280) <+ transition((code_tot > 280) ? 0.8 : 0.0, 0.0, 50p, 50p);
    V(c281) <+ transition((code_tot > 281) ? 0.8 : 0.0, 0.0, 50p, 50p);
    V(c282) <+ transition((code_tot > 282) ? 0.8 : 0.0, 0.0, 50p, 50p);
    V(c283) <+ transition((code_tot > 283) ? 0.8 : 0.0, 0.0, 50p, 50p);
    V(c284) <+ transition((code_tot > 284) ? 0.8 : 0.0, 0.0, 50p, 50p);
    V(c285) <+ transition((code_tot > 285) ? 0.8 : 0.0, 0.0, 50p, 50p);
    V(c286) <+ transition((code_tot > 286) ? 0.8 : 0.0, 0.0, 50p, 50p);
    V(c287) <+ transition((code_tot > 287) ? 0.8 : 0.0, 0.0, 50p, 50p);
    V(c288) <+ transition((code_tot > 288) ? 0.8 : 0.0, 0.0, 50p, 50p);
    V(c289) <+ transition((code_tot > 289) ? 0.8 : 0.0, 0.0, 50p, 50p);
    V(c290) <+ transition((code_tot > 290) ? 0.8 : 0.0, 0.0, 50p, 50p);
    V(c291) <+ transition((code_tot > 291) ? 0.8 : 0.0, 0.0, 50p, 50p);
    V(c292) <+ transition((code_tot > 292) ? 0.8 : 0.0, 0.0, 50p, 50p);
    V(c293) <+ transition((code_tot > 293) ? 0.8 : 0.0, 0.0, 50p, 50p);
    V(c294) <+ transition((code_tot > 294) ? 0.8 : 0.0, 0.0, 50p, 50p);
    V(c295) <+ transition((code_tot > 295) ? 0.8 : 0.0, 0.0, 50p, 50p);
    V(c296) <+ transition((code_tot > 296) ? 0.8 : 0.0, 0.0, 50p, 50p);
    V(c297) <+ transition((code_tot > 297) ? 0.8 : 0.0, 0.0, 50p, 50p);
    V(c298) <+ transition((code_tot > 298) ? 0.8 : 0.0, 0.0, 50p, 50p);
    V(c299) <+ transition((code_tot > 299) ? 0.8 : 0.0, 0.0, 50p, 50p);
    V(c300) <+ transition((code_tot > 300) ? 0.8 : 0.0, 0.0, 50p, 50p);
    V(c301) <+ transition((code_tot > 301) ? 0.8 : 0.0, 0.0, 50p, 50p);
    V(c302) <+ transition((code_tot > 302) ? 0.8 : 0.0, 0.0, 50p, 50p);
    V(c303) <+ transition((code_tot > 303) ? 0.8 : 0.0, 0.0, 50p, 50p);
    V(c304) <+ transition((code_tot > 304) ? 0.8 : 0.0, 0.0, 50p, 50p);
    V(c305) <+ transition((code_tot > 305) ? 0.8 : 0.0, 0.0, 50p, 50p);
    V(c306) <+ transition((code_tot > 306) ? 0.8 : 0.0, 0.0, 50p, 50p);
    V(c307) <+ transition((code_tot > 307) ? 0.8 : 0.0, 0.0, 50p, 50p);
    V(c308) <+ transition((code_tot > 308) ? 0.8 : 0.0, 0.0, 50p, 50p);
    V(c309) <+ transition((code_tot > 309) ? 0.8 : 0.0, 0.0, 50p, 50p);
    V(c310) <+ transition((code_tot > 310) ? 0.8 : 0.0, 0.0, 50p, 50p);
    V(c311) <+ transition((code_tot > 311) ? 0.8 : 0.0, 0.0, 50p, 50p);
    V(c312) <+ transition((code_tot > 312) ? 0.8 : 0.0, 0.0, 50p, 50p);
    V(c313) <+ transition((code_tot > 313) ? 0.8 : 0.0, 0.0, 50p, 50p);
    V(c314) <+ transition((code_tot > 314) ? 0.8 : 0.0, 0.0, 50p, 50p);
    V(c315) <+ transition((code_tot > 315) ? 0.8 : 0.0, 0.0, 50p, 50p);
    V(c316) <+ transition((code_tot > 316) ? 0.8 : 0.0, 0.0, 50p, 50p);
    V(c317) <+ transition((code_tot > 317) ? 0.8 : 0.0, 0.0, 50p, 50p);
    V(c318) <+ transition((code_tot > 318) ? 0.8 : 0.0, 0.0, 50p, 50p);
    V(c319) <+ transition((code_tot > 319) ? 0.8 : 0.0, 0.0, 50p, 50p);
    V(c320) <+ transition((code_tot > 320) ? 0.8 : 0.0, 0.0, 50p, 50p);
    V(c321) <+ transition((code_tot > 321) ? 0.8 : 0.0, 0.0, 50p, 50p);
    V(c322) <+ transition((code_tot > 322) ? 0.8 : 0.0, 0.0, 50p, 50p);
    V(c323) <+ transition((code_tot > 323) ? 0.8 : 0.0, 0.0, 50p, 50p);
    V(c324) <+ transition((code_tot > 324) ? 0.8 : 0.0, 0.0, 50p, 50p);
    V(c325) <+ transition((code_tot > 325) ? 0.8 : 0.0, 0.0, 50p, 50p);
    V(c326) <+ transition((code_tot > 326) ? 0.8 : 0.0, 0.0, 50p, 50p);
    V(c327) <+ transition((code_tot > 327) ? 0.8 : 0.0, 0.0, 50p, 50p);
    V(c328) <+ transition((code_tot > 328) ? 0.8 : 0.0, 0.0, 50p, 50p);
    V(c329) <+ transition((code_tot > 329) ? 0.8 : 0.0, 0.0, 50p, 50p);
    V(c330) <+ transition((code_tot > 330) ? 0.8 : 0.0, 0.0, 50p, 50p);
    V(c331) <+ transition((code_tot > 331) ? 0.8 : 0.0, 0.0, 50p, 50p);
    V(c332) <+ transition((code_tot > 332) ? 0.8 : 0.0, 0.0, 50p, 50p);
    V(c333) <+ transition((code_tot > 333) ? 0.8 : 0.0, 0.0, 50p, 50p);
    V(c334) <+ transition((code_tot > 334) ? 0.8 : 0.0, 0.0, 50p, 50p);
    V(c335) <+ transition((code_tot > 335) ? 0.8 : 0.0, 0.0, 50p, 50p);
    V(c336) <+ transition((code_tot > 336) ? 0.8 : 0.0, 0.0, 50p, 50p);
    V(c337) <+ transition((code_tot > 337) ? 0.8 : 0.0, 0.0, 50p, 50p);
    V(c338) <+ transition((code_tot > 338) ? 0.8 : 0.0, 0.0, 50p, 50p);
    V(c339) <+ transition((code_tot > 339) ? 0.8 : 0.0, 0.0, 50p, 50p);
    V(c340) <+ transition((code_tot > 340) ? 0.8 : 0.0, 0.0, 50p, 50p);
    V(c341) <+ transition((code_tot > 341) ? 0.8 : 0.0, 0.0, 50p, 50p);
    V(c342) <+ transition((code_tot > 342) ? 0.8 : 0.0, 0.0, 50p, 50p);
    V(c343) <+ transition((code_tot > 343) ? 0.8 : 0.0, 0.0, 50p, 50p);
    V(c344) <+ transition((code_tot > 344) ? 0.8 : 0.0, 0.0, 50p, 50p);
    V(c345) <+ transition((code_tot > 345) ? 0.8 : 0.0, 0.0, 50p, 50p);
    V(c346) <+ transition((code_tot > 346) ? 0.8 : 0.0, 0.0, 50p, 50p);
    V(c347) <+ transition((code_tot > 347) ? 0.8 : 0.0, 0.0, 50p, 50p);
    V(c348) <+ transition((code_tot > 348) ? 0.8 : 0.0, 0.0, 50p, 50p);
    V(c349) <+ transition((code_tot > 349) ? 0.8 : 0.0, 0.0, 50p, 50p);
    V(c350) <+ transition((code_tot > 350) ? 0.8 : 0.0, 0.0, 50p, 50p);
    V(c351) <+ transition((code_tot > 351) ? 0.8 : 0.0, 0.0, 50p, 50p);
    V(c352) <+ transition((code_tot > 352) ? 0.8 : 0.0, 0.0, 50p, 50p);
    V(c353) <+ transition((code_tot > 353) ? 0.8 : 0.0, 0.0, 50p, 50p);
    V(c354) <+ transition((code_tot > 354) ? 0.8 : 0.0, 0.0, 50p, 50p);
    V(c355) <+ transition((code_tot > 355) ? 0.8 : 0.0, 0.0, 50p, 50p);
    V(c356) <+ transition((code_tot > 356) ? 0.8 : 0.0, 0.0, 50p, 50p);
    V(c357) <+ transition((code_tot > 357) ? 0.8 : 0.0, 0.0, 50p, 50p);
    V(c358) <+ transition((code_tot > 358) ? 0.8 : 0.0, 0.0, 50p, 50p);
    V(c359) <+ transition((code_tot > 359) ? 0.8 : 0.0, 0.0, 50p, 50p);
    V(c360) <+ transition((code_tot > 360) ? 0.8 : 0.0, 0.0, 50p, 50p);
    V(c361) <+ transition((code_tot > 361) ? 0.8 : 0.0, 0.0, 50p, 50p);
    V(c362) <+ transition((code_tot > 362) ? 0.8 : 0.0, 0.0, 50p, 50p);
    V(c363) <+ transition((code_tot > 363) ? 0.8 : 0.0, 0.0, 50p, 50p);
    V(c364) <+ transition((code_tot > 364) ? 0.8 : 0.0, 0.0, 50p, 50p);
    V(c365) <+ transition((code_tot > 365) ? 0.8 : 0.0, 0.0, 50p, 50p);
    V(c366) <+ transition((code_tot > 366) ? 0.8 : 0.0, 0.0, 50p, 50p);
    V(c367) <+ transition((code_tot > 367) ? 0.8 : 0.0, 0.0, 50p, 50p);
    V(c368) <+ transition((code_tot > 368) ? 0.8 : 0.0, 0.0, 50p, 50p);
    V(c369) <+ transition((code_tot > 369) ? 0.8 : 0.0, 0.0, 50p, 50p);
    V(c370) <+ transition((code_tot > 370) ? 0.8 : 0.0, 0.0, 50p, 50p);
    V(c371) <+ transition((code_tot > 371) ? 0.8 : 0.0, 0.0, 50p, 50p);
    V(c372) <+ transition((code_tot > 372) ? 0.8 : 0.0, 0.0, 50p, 50p);
    V(c373) <+ transition((code_tot > 373) ? 0.8 : 0.0, 0.0, 50p, 50p);
    V(c374) <+ transition((code_tot > 374) ? 0.8 : 0.0, 0.0, 50p, 50p);
    V(c375) <+ transition((code_tot > 375) ? 0.8 : 0.0, 0.0, 50p, 50p);
    V(c376) <+ transition((code_tot > 376) ? 0.8 : 0.0, 0.0, 50p, 50p);
    V(c377) <+ transition((code_tot > 377) ? 0.8 : 0.0, 0.0, 50p, 50p);
    V(c378) <+ transition((code_tot > 378) ? 0.8 : 0.0, 0.0, 50p, 50p);
    V(c379) <+ transition((code_tot > 379) ? 0.8 : 0.0, 0.0, 50p, 50p);
    V(c380) <+ transition((code_tot > 380) ? 0.8 : 0.0, 0.0, 50p, 50p);
    V(c381) <+ transition((code_tot > 381) ? 0.8 : 0.0, 0.0, 50p, 50p);
    V(c382) <+ transition((code_tot > 382) ? 0.8 : 0.0, 0.0, 50p, 50p);
    V(c383) <+ transition((code_tot > 383) ? 0.8 : 0.0, 0.0, 50p, 50p);
    V(c384) <+ transition((code_tot > 384) ? 0.8 : 0.0, 0.0, 50p, 50p);
    V(c385) <+ transition((code_tot > 385) ? 0.8 : 0.0, 0.0, 50p, 50p);
    V(c386) <+ transition((code_tot > 386) ? 0.8 : 0.0, 0.0, 50p, 50p);
    V(c387) <+ transition((code_tot > 387) ? 0.8 : 0.0, 0.0, 50p, 50p);
    V(c388) <+ transition((code_tot > 388) ? 0.8 : 0.0, 0.0, 50p, 50p);
    V(c389) <+ transition((code_tot > 389) ? 0.8 : 0.0, 0.0, 50p, 50p);
    V(c390) <+ transition((code_tot > 390) ? 0.8 : 0.0, 0.0, 50p, 50p);
    V(c391) <+ transition((code_tot > 391) ? 0.8 : 0.0, 0.0, 50p, 50p);
    V(c392) <+ transition((code_tot > 392) ? 0.8 : 0.0, 0.0, 50p, 50p);
    V(c393) <+ transition((code_tot > 393) ? 0.8 : 0.0, 0.0, 50p, 50p);
    V(c394) <+ transition((code_tot > 394) ? 0.8 : 0.0, 0.0, 50p, 50p);
    V(c395) <+ transition((code_tot > 395) ? 0.8 : 0.0, 0.0, 50p, 50p);
    V(c396) <+ transition((code_tot > 396) ? 0.8 : 0.0, 0.0, 50p, 50p);
    V(c397) <+ transition((code_tot > 397) ? 0.8 : 0.0, 0.0, 50p, 50p);
    V(c398) <+ transition((code_tot > 398) ? 0.8 : 0.0, 0.0, 50p, 50p);
    V(c399) <+ transition((code_tot > 399) ? 0.8 : 0.0, 0.0, 50p, 50p);
    V(c400) <+ transition((code_tot > 400) ? 0.8 : 0.0, 0.0, 50p, 50p);
    V(c401) <+ transition((code_tot > 401) ? 0.8 : 0.0, 0.0, 50p, 50p);
    V(c402) <+ transition((code_tot > 402) ? 0.8 : 0.0, 0.0, 50p, 50p);
    V(c403) <+ transition((code_tot > 403) ? 0.8 : 0.0, 0.0, 50p, 50p);
    V(c404) <+ transition((code_tot > 404) ? 0.8 : 0.0, 0.0, 50p, 50p);
    V(c405) <+ transition((code_tot > 405) ? 0.8 : 0.0, 0.0, 50p, 50p);
    V(c406) <+ transition((code_tot > 406) ? 0.8 : 0.0, 0.0, 50p, 50p);
    V(c407) <+ transition((code_tot > 407) ? 0.8 : 0.0, 0.0, 50p, 50p);
    V(c408) <+ transition((code_tot > 408) ? 0.8 : 0.0, 0.0, 50p, 50p);
    V(c409) <+ transition((code_tot > 409) ? 0.8 : 0.0, 0.0, 50p, 50p);
    V(c410) <+ transition((code_tot > 410) ? 0.8 : 0.0, 0.0, 50p, 50p);
    V(c411) <+ transition((code_tot > 411) ? 0.8 : 0.0, 0.0, 50p, 50p);
    V(c412) <+ transition((code_tot > 412) ? 0.8 : 0.0, 0.0, 50p, 50p);
    V(c413) <+ transition((code_tot > 413) ? 0.8 : 0.0, 0.0, 50p, 50p);
    V(c414) <+ transition((code_tot > 414) ? 0.8 : 0.0, 0.0, 50p, 50p);
    V(c415) <+ transition((code_tot > 415) ? 0.8 : 0.0, 0.0, 50p, 50p);
    V(c416) <+ transition((code_tot > 416) ? 0.8 : 0.0, 0.0, 50p, 50p);
    V(c417) <+ transition((code_tot > 417) ? 0.8 : 0.0, 0.0, 50p, 50p);
    V(c418) <+ transition((code_tot > 418) ? 0.8 : 0.0, 0.0, 50p, 50p);
    V(c419) <+ transition((code_tot > 419) ? 0.8 : 0.0, 0.0, 50p, 50p);
    V(c420) <+ transition((code_tot > 420) ? 0.8 : 0.0, 0.0, 50p, 50p);
    V(c421) <+ transition((code_tot > 421) ? 0.8 : 0.0, 0.0, 50p, 50p);
    V(c422) <+ transition((code_tot > 422) ? 0.8 : 0.0, 0.0, 50p, 50p);
    V(c423) <+ transition((code_tot > 423) ? 0.8 : 0.0, 0.0, 50p, 50p);
    V(c424) <+ transition((code_tot > 424) ? 0.8 : 0.0, 0.0, 50p, 50p);
    V(c425) <+ transition((code_tot > 425) ? 0.8 : 0.0, 0.0, 50p, 50p);
    V(c426) <+ transition((code_tot > 426) ? 0.8 : 0.0, 0.0, 50p, 50p);
    V(c427) <+ transition((code_tot > 427) ? 0.8 : 0.0, 0.0, 50p, 50p);
    V(c428) <+ transition((code_tot > 428) ? 0.8 : 0.0, 0.0, 50p, 50p);
    V(c429) <+ transition((code_tot > 429) ? 0.8 : 0.0, 0.0, 50p, 50p);
    V(c430) <+ transition((code_tot > 430) ? 0.8 : 0.0, 0.0, 50p, 50p);
    V(c431) <+ transition((code_tot > 431) ? 0.8 : 0.0, 0.0, 50p, 50p);
    V(c432) <+ transition((code_tot > 432) ? 0.8 : 0.0, 0.0, 50p, 50p);
    V(c433) <+ transition((code_tot > 433) ? 0.8 : 0.0, 0.0, 50p, 50p);
    V(c434) <+ transition((code_tot > 434) ? 0.8 : 0.0, 0.0, 50p, 50p);
    V(c435) <+ transition((code_tot > 435) ? 0.8 : 0.0, 0.0, 50p, 50p);
    V(c436) <+ transition((code_tot > 436) ? 0.8 : 0.0, 0.0, 50p, 50p);
    V(c437) <+ transition((code_tot > 437) ? 0.8 : 0.0, 0.0, 50p, 50p);
    V(c438) <+ transition((code_tot > 438) ? 0.8 : 0.0, 0.0, 50p, 50p);
    V(c439) <+ transition((code_tot > 439) ? 0.8 : 0.0, 0.0, 50p, 50p);
    V(c440) <+ transition((code_tot > 440) ? 0.8 : 0.0, 0.0, 50p, 50p);
    V(c441) <+ transition((code_tot > 441) ? 0.8 : 0.0, 0.0, 50p, 50p);
    V(c442) <+ transition((code_tot > 442) ? 0.8 : 0.0, 0.0, 50p, 50p);
    V(c443) <+ transition((code_tot > 443) ? 0.8 : 0.0, 0.0, 50p, 50p);
    V(c444) <+ transition((code_tot > 444) ? 0.8 : 0.0, 0.0, 50p, 50p);
    V(c445) <+ transition((code_tot > 445) ? 0.8 : 0.0, 0.0, 50p, 50p);
    V(c446) <+ transition((code_tot > 446) ? 0.8 : 0.0, 0.0, 50p, 50p);
    V(c447) <+ transition((code_tot > 447) ? 0.8 : 0.0, 0.0, 50p, 50p);
    V(c448) <+ transition((code_tot > 448) ? 0.8 : 0.0, 0.0, 50p, 50p);
    V(c449) <+ transition((code_tot > 449) ? 0.8 : 0.0, 0.0, 50p, 50p);
    V(c450) <+ transition((code_tot > 450) ? 0.8 : 0.0, 0.0, 50p, 50p);
    V(c451) <+ transition((code_tot > 451) ? 0.8 : 0.0, 0.0, 50p, 50p);
    V(c452) <+ transition((code_tot > 452) ? 0.8 : 0.0, 0.0, 50p, 50p);
    V(c453) <+ transition((code_tot > 453) ? 0.8 : 0.0, 0.0, 50p, 50p);
    V(c454) <+ transition((code_tot > 454) ? 0.8 : 0.0, 0.0, 50p, 50p);
    V(c455) <+ transition((code_tot > 455) ? 0.8 : 0.0, 0.0, 50p, 50p);
    V(c456) <+ transition((code_tot > 456) ? 0.8 : 0.0, 0.0, 50p, 50p);
    V(c457) <+ transition((code_tot > 457) ? 0.8 : 0.0, 0.0, 50p, 50p);
    V(c458) <+ transition((code_tot > 458) ? 0.8 : 0.0, 0.0, 50p, 50p);
    V(c459) <+ transition((code_tot > 459) ? 0.8 : 0.0, 0.0, 50p, 50p);
    V(c460) <+ transition((code_tot > 460) ? 0.8 : 0.0, 0.0, 50p, 50p);
    V(c461) <+ transition((code_tot > 461) ? 0.8 : 0.0, 0.0, 50p, 50p);
    V(c462) <+ transition((code_tot > 462) ? 0.8 : 0.0, 0.0, 50p, 50p);
    V(c463) <+ transition((code_tot > 463) ? 0.8 : 0.0, 0.0, 50p, 50p);
    V(c464) <+ transition((code_tot > 464) ? 0.8 : 0.0, 0.0, 50p, 50p);
    V(c465) <+ transition((code_tot > 465) ? 0.8 : 0.0, 0.0, 50p, 50p);
    V(c466) <+ transition((code_tot > 466) ? 0.8 : 0.0, 0.0, 50p, 50p);
    V(c467) <+ transition((code_tot > 467) ? 0.8 : 0.0, 0.0, 50p, 50p);
    V(c468) <+ transition((code_tot > 468) ? 0.8 : 0.0, 0.0, 50p, 50p);
    V(c469) <+ transition((code_tot > 469) ? 0.8 : 0.0, 0.0, 50p, 50p);
    V(c470) <+ transition((code_tot > 470) ? 0.8 : 0.0, 0.0, 50p, 50p);
    V(c471) <+ transition((code_tot > 471) ? 0.8 : 0.0, 0.0, 50p, 50p);
    V(c472) <+ transition((code_tot > 472) ? 0.8 : 0.0, 0.0, 50p, 50p);
    V(c473) <+ transition((code_tot > 473) ? 0.8 : 0.0, 0.0, 50p, 50p);
    V(c474) <+ transition((code_tot > 474) ? 0.8 : 0.0, 0.0, 50p, 50p);
    V(c475) <+ transition((code_tot > 475) ? 0.8 : 0.0, 0.0, 50p, 50p);
    V(c476) <+ transition((code_tot > 476) ? 0.8 : 0.0, 0.0, 50p, 50p);
    V(c477) <+ transition((code_tot > 477) ? 0.8 : 0.0, 0.0, 50p, 50p);
    V(c478) <+ transition((code_tot > 478) ? 0.8 : 0.0, 0.0, 50p, 50p);
    V(c479) <+ transition((code_tot > 479) ? 0.8 : 0.0, 0.0, 50p, 50p);
    V(c480) <+ transition((code_tot > 480) ? 0.8 : 0.0, 0.0, 50p, 50p);
    V(c481) <+ transition((code_tot > 481) ? 0.8 : 0.0, 0.0, 50p, 50p);
    V(c482) <+ transition((code_tot > 482) ? 0.8 : 0.0, 0.0, 50p, 50p);
    V(c483) <+ transition((code_tot > 483) ? 0.8 : 0.0, 0.0, 50p, 50p);
    V(c484) <+ transition((code_tot > 484) ? 0.8 : 0.0, 0.0, 50p, 50p);
    V(c485) <+ transition((code_tot > 485) ? 0.8 : 0.0, 0.0, 50p, 50p);
    V(c486) <+ transition((code_tot > 486) ? 0.8 : 0.0, 0.0, 50p, 50p);
    V(c487) <+ transition((code_tot > 487) ? 0.8 : 0.0, 0.0, 50p, 50p);
    V(c488) <+ transition((code_tot > 488) ? 0.8 : 0.0, 0.0, 50p, 50p);
    V(c489) <+ transition((code_tot > 489) ? 0.8 : 0.0, 0.0, 50p, 50p);
    V(c490) <+ transition((code_tot > 490) ? 0.8 : 0.0, 0.0, 50p, 50p);
    V(c491) <+ transition((code_tot > 491) ? 0.8 : 0.0, 0.0, 50p, 50p);
    V(c492) <+ transition((code_tot > 492) ? 0.8 : 0.0, 0.0, 50p, 50p);
    V(c493) <+ transition((code_tot > 493) ? 0.8 : 0.0, 0.0, 50p, 50p);
    V(c494) <+ transition((code_tot > 494) ? 0.8 : 0.0, 0.0, 50p, 50p);
    V(c495) <+ transition((code_tot > 495) ? 0.8 : 0.0, 0.0, 50p, 50p);
    V(c496) <+ transition((code_tot > 496) ? 0.8 : 0.0, 0.0, 50p, 50p);
    V(c497) <+ transition((code_tot > 497) ? 0.8 : 0.0, 0.0, 50p, 50p);
    V(c498) <+ transition((code_tot > 498) ? 0.8 : 0.0, 0.0, 50p, 50p);
    V(c499) <+ transition((code_tot > 499) ? 0.8 : 0.0, 0.0, 50p, 50p);
    V(c500) <+ transition((code_tot > 500) ? 0.8 : 0.0, 0.0, 50p, 50p);
    V(c501) <+ transition((code_tot > 501) ? 0.8 : 0.0, 0.0, 50p, 50p);
    V(c502) <+ transition((code_tot > 502) ? 0.8 : 0.0, 0.0, 50p, 50p);
    V(c503) <+ transition((code_tot > 503) ? 0.8 : 0.0, 0.0, 50p, 50p);
    V(c504) <+ transition((code_tot > 504) ? 0.8 : 0.0, 0.0, 50p, 50p);
    V(c505) <+ transition((code_tot > 505) ? 0.8 : 0.0, 0.0, 50p, 50p);
    V(c506) <+ transition((code_tot > 506) ? 0.8 : 0.0, 0.0, 50p, 50p);
    V(c507) <+ transition((code_tot > 507) ? 0.8 : 0.0, 0.0, 50p, 50p);
    V(c508) <+ transition((code_tot > 508) ? 0.8 : 0.0, 0.0, 50p, 50p);
    V(c509) <+ transition((code_tot > 509) ? 0.8 : 0.0, 0.0, 50p, 50p);
    V(c510) <+ transition((code_tot > 510) ? 0.8 : 0.0, 0.0, 50p, 50p);
    V(c511) <+ transition((code_tot > 511) ? 0.8 : 0.0, 0.0, 50p, 50p);
    V(c512) <+ transition((code_tot > 512) ? 0.8 : 0.0, 0.0, 50p, 50p);
    V(c513) <+ transition((code_tot > 513) ? 0.8 : 0.0, 0.0, 50p, 50p);
    V(c514) <+ transition((code_tot > 514) ? 0.8 : 0.0, 0.0, 50p, 50p);
    V(c515) <+ transition((code_tot > 515) ? 0.8 : 0.0, 0.0, 50p, 50p);
    V(c516) <+ transition((code_tot > 516) ? 0.8 : 0.0, 0.0, 50p, 50p);
    V(c517) <+ transition((code_tot > 517) ? 0.8 : 0.0, 0.0, 50p, 50p);
    V(c518) <+ transition((code_tot > 518) ? 0.8 : 0.0, 0.0, 50p, 50p);
    V(c519) <+ transition((code_tot > 519) ? 0.8 : 0.0, 0.0, 50p, 50p);
    V(c520) <+ transition((code_tot > 520) ? 0.8 : 0.0, 0.0, 50p, 50p);
    V(c521) <+ transition((code_tot > 521) ? 0.8 : 0.0, 0.0, 50p, 50p);
    V(c522) <+ transition((code_tot > 522) ? 0.8 : 0.0, 0.0, 50p, 50p);
    V(c523) <+ transition((code_tot > 523) ? 0.8 : 0.0, 0.0, 50p, 50p);
    V(c524) <+ transition((code_tot > 524) ? 0.8 : 0.0, 0.0, 50p, 50p);
    V(c525) <+ transition((code_tot > 525) ? 0.8 : 0.0, 0.0, 50p, 50p);
    V(c526) <+ transition((code_tot > 526) ? 0.8 : 0.0, 0.0, 50p, 50p);
    V(c527) <+ transition((code_tot > 527) ? 0.8 : 0.0, 0.0, 50p, 50p);
    V(c528) <+ transition((code_tot > 528) ? 0.8 : 0.0, 0.0, 50p, 50p);
    V(c529) <+ transition((code_tot > 529) ? 0.8 : 0.0, 0.0, 50p, 50p);
    V(c530) <+ transition((code_tot > 530) ? 0.8 : 0.0, 0.0, 50p, 50p);
    V(c531) <+ transition((code_tot > 531) ? 0.8 : 0.0, 0.0, 50p, 50p);
    V(c532) <+ transition((code_tot > 532) ? 0.8 : 0.0, 0.0, 50p, 50p);
    V(c533) <+ transition((code_tot > 533) ? 0.8 : 0.0, 0.0, 50p, 50p);
    V(c534) <+ transition((code_tot > 534) ? 0.8 : 0.0, 0.0, 50p, 50p);
    V(c535) <+ transition((code_tot > 535) ? 0.8 : 0.0, 0.0, 50p, 50p);
    V(c536) <+ transition((code_tot > 536) ? 0.8 : 0.0, 0.0, 50p, 50p);
    V(c537) <+ transition((code_tot > 537) ? 0.8 : 0.0, 0.0, 50p, 50p);
    V(c538) <+ transition((code_tot > 538) ? 0.8 : 0.0, 0.0, 50p, 50p);
    V(c539) <+ transition((code_tot > 539) ? 0.8 : 0.0, 0.0, 50p, 50p);
    V(c540) <+ transition((code_tot > 540) ? 0.8 : 0.0, 0.0, 50p, 50p);
    V(c541) <+ transition((code_tot > 541) ? 0.8 : 0.0, 0.0, 50p, 50p);
    V(c542) <+ transition((code_tot > 542) ? 0.8 : 0.0, 0.0, 50p, 50p);
    V(c543) <+ transition((code_tot > 543) ? 0.8 : 0.0, 0.0, 50p, 50p);
    V(c544) <+ transition((code_tot > 544) ? 0.8 : 0.0, 0.0, 50p, 50p);
    V(c545) <+ transition((code_tot > 545) ? 0.8 : 0.0, 0.0, 50p, 50p);
    V(c546) <+ transition((code_tot > 546) ? 0.8 : 0.0, 0.0, 50p, 50p);
    V(c547) <+ transition((code_tot > 547) ? 0.8 : 0.0, 0.0, 50p, 50p);
    V(c548) <+ transition((code_tot > 548) ? 0.8 : 0.0, 0.0, 50p, 50p);
    V(c549) <+ transition((code_tot > 549) ? 0.8 : 0.0, 0.0, 50p, 50p);
    V(c550) <+ transition((code_tot > 550) ? 0.8 : 0.0, 0.0, 50p, 50p);
    V(c551) <+ transition((code_tot > 551) ? 0.8 : 0.0, 0.0, 50p, 50p);
    V(c552) <+ transition((code_tot > 552) ? 0.8 : 0.0, 0.0, 50p, 50p);
    V(c553) <+ transition((code_tot > 553) ? 0.8 : 0.0, 0.0, 50p, 50p);
    V(c554) <+ transition((code_tot > 554) ? 0.8 : 0.0, 0.0, 50p, 50p);
    V(c555) <+ transition((code_tot > 555) ? 0.8 : 0.0, 0.0, 50p, 50p);
    V(c556) <+ transition((code_tot > 556) ? 0.8 : 0.0, 0.0, 50p, 50p);
    V(c557) <+ transition((code_tot > 557) ? 0.8 : 0.0, 0.0, 50p, 50p);
    V(c558) <+ transition((code_tot > 558) ? 0.8 : 0.0, 0.0, 50p, 50p);
    V(c559) <+ transition((code_tot > 559) ? 0.8 : 0.0, 0.0, 50p, 50p);
    V(c560) <+ transition((code_tot > 560) ? 0.8 : 0.0, 0.0, 50p, 50p);
    V(c561) <+ transition((code_tot > 561) ? 0.8 : 0.0, 0.0, 50p, 50p);
    V(c562) <+ transition((code_tot > 562) ? 0.8 : 0.0, 0.0, 50p, 50p);
    V(c563) <+ transition((code_tot > 563) ? 0.8 : 0.0, 0.0, 50p, 50p);
    V(c564) <+ transition((code_tot > 564) ? 0.8 : 0.0, 0.0, 50p, 50p);
    V(c565) <+ transition((code_tot > 565) ? 0.8 : 0.0, 0.0, 50p, 50p);
    V(c566) <+ transition((code_tot > 566) ? 0.8 : 0.0, 0.0, 50p, 50p);
    V(c567) <+ transition((code_tot > 567) ? 0.8 : 0.0, 0.0, 50p, 50p);
    V(c568) <+ transition((code_tot > 568) ? 0.8 : 0.0, 0.0, 50p, 50p);
    V(c569) <+ transition((code_tot > 569) ? 0.8 : 0.0, 0.0, 50p, 50p);
    V(c570) <+ transition((code_tot > 570) ? 0.8 : 0.0, 0.0, 50p, 50p);
    V(c571) <+ transition((code_tot > 571) ? 0.8 : 0.0, 0.0, 50p, 50p);
    V(c572) <+ transition((code_tot > 572) ? 0.8 : 0.0, 0.0, 50p, 50p);
    V(c573) <+ transition((code_tot > 573) ? 0.8 : 0.0, 0.0, 50p, 50p);
    V(c574) <+ transition((code_tot > 574) ? 0.8 : 0.0, 0.0, 50p, 50p);
    V(c575) <+ transition((code_tot > 575) ? 0.8 : 0.0, 0.0, 50p, 50p);
    V(c576) <+ transition((code_tot > 576) ? 0.8 : 0.0, 0.0, 50p, 50p);
    V(c577) <+ transition((code_tot > 577) ? 0.8 : 0.0, 0.0, 50p, 50p);
    V(c578) <+ transition((code_tot > 578) ? 0.8 : 0.0, 0.0, 50p, 50p);
    V(c579) <+ transition((code_tot > 579) ? 0.8 : 0.0, 0.0, 50p, 50p);
    V(c580) <+ transition((code_tot > 580) ? 0.8 : 0.0, 0.0, 50p, 50p);
    V(c581) <+ transition((code_tot > 581) ? 0.8 : 0.0, 0.0, 50p, 50p);
    V(c582) <+ transition((code_tot > 582) ? 0.8 : 0.0, 0.0, 50p, 50p);
    V(c583) <+ transition((code_tot > 583) ? 0.8 : 0.0, 0.0, 50p, 50p);
    V(c584) <+ transition((code_tot > 584) ? 0.8 : 0.0, 0.0, 50p, 50p);
    V(c585) <+ transition((code_tot > 585) ? 0.8 : 0.0, 0.0, 50p, 50p);
    V(c586) <+ transition((code_tot > 586) ? 0.8 : 0.0, 0.0, 50p, 50p);
    V(c587) <+ transition((code_tot > 587) ? 0.8 : 0.0, 0.0, 50p, 50p);
    V(c588) <+ transition((code_tot > 588) ? 0.8 : 0.0, 0.0, 50p, 50p);
    V(c589) <+ transition((code_tot > 589) ? 0.8 : 0.0, 0.0, 50p, 50p);
    V(c590) <+ transition((code_tot > 590) ? 0.8 : 0.0, 0.0, 50p, 50p);
    V(c591) <+ transition((code_tot > 591) ? 0.8 : 0.0, 0.0, 50p, 50p);
    V(c592) <+ transition((code_tot > 592) ? 0.8 : 0.0, 0.0, 50p, 50p);
    V(c593) <+ transition((code_tot > 593) ? 0.8 : 0.0, 0.0, 50p, 50p);
    V(c594) <+ transition((code_tot > 594) ? 0.8 : 0.0, 0.0, 50p, 50p);
    V(c595) <+ transition((code_tot > 595) ? 0.8 : 0.0, 0.0, 50p, 50p);
    V(c596) <+ transition((code_tot > 596) ? 0.8 : 0.0, 0.0, 50p, 50p);
    V(c597) <+ transition((code_tot > 597) ? 0.8 : 0.0, 0.0, 50p, 50p);
    V(c598) <+ transition((code_tot > 598) ? 0.8 : 0.0, 0.0, 50p, 50p);
    V(c599) <+ transition((code_tot > 599) ? 0.8 : 0.0, 0.0, 50p, 50p);
    V(c600) <+ transition((code_tot > 600) ? 0.8 : 0.0, 0.0, 50p, 50p);
    V(c601) <+ transition((code_tot > 601) ? 0.8 : 0.0, 0.0, 50p, 50p);
    V(c602) <+ transition((code_tot > 602) ? 0.8 : 0.0, 0.0, 50p, 50p);
    V(c603) <+ transition((code_tot > 603) ? 0.8 : 0.0, 0.0, 50p, 50p);
    V(c604) <+ transition((code_tot > 604) ? 0.8 : 0.0, 0.0, 50p, 50p);
    V(c605) <+ transition((code_tot > 605) ? 0.8 : 0.0, 0.0, 50p, 50p);
    V(c606) <+ transition((code_tot > 606) ? 0.8 : 0.0, 0.0, 50p, 50p);
    V(c607) <+ transition((code_tot > 607) ? 0.8 : 0.0, 0.0, 50p, 50p);
    V(c608) <+ transition((code_tot > 608) ? 0.8 : 0.0, 0.0, 50p, 50p);
    V(c609) <+ transition((code_tot > 609) ? 0.8 : 0.0, 0.0, 50p, 50p);
    V(c610) <+ transition((code_tot > 610) ? 0.8 : 0.0, 0.0, 50p, 50p);
    V(c611) <+ transition((code_tot > 611) ? 0.8 : 0.0, 0.0, 50p, 50p);
    V(c612) <+ transition((code_tot > 612) ? 0.8 : 0.0, 0.0, 50p, 50p);
    V(c613) <+ transition((code_tot > 613) ? 0.8 : 0.0, 0.0, 50p, 50p);
    V(c614) <+ transition((code_tot > 614) ? 0.8 : 0.0, 0.0, 50p, 50p);
    V(c615) <+ transition((code_tot > 615) ? 0.8 : 0.0, 0.0, 50p, 50p);
    V(c616) <+ transition((code_tot > 616) ? 0.8 : 0.0, 0.0, 50p, 50p);
    V(c617) <+ transition((code_tot > 617) ? 0.8 : 0.0, 0.0, 50p, 50p);
    V(c618) <+ transition((code_tot > 618) ? 0.8 : 0.0, 0.0, 50p, 50p);
    V(c619) <+ transition((code_tot > 619) ? 0.8 : 0.0, 0.0, 50p, 50p);
    V(c620) <+ transition((code_tot > 620) ? 0.8 : 0.0, 0.0, 50p, 50p);
    V(c621) <+ transition((code_tot > 621) ? 0.8 : 0.0, 0.0, 50p, 50p);
    V(c622) <+ transition((code_tot > 622) ? 0.8 : 0.0, 0.0, 50p, 50p);
    V(c623) <+ transition((code_tot > 623) ? 0.8 : 0.0, 0.0, 50p, 50p);
    V(c624) <+ transition((code_tot > 624) ? 0.8 : 0.0, 0.0, 50p, 50p);
    V(c625) <+ transition((code_tot > 625) ? 0.8 : 0.0, 0.0, 50p, 50p);
    V(c626) <+ transition((code_tot > 626) ? 0.8 : 0.0, 0.0, 50p, 50p);
    V(c627) <+ transition((code_tot > 627) ? 0.8 : 0.0, 0.0, 50p, 50p);
    V(c628) <+ transition((code_tot > 628) ? 0.8 : 0.0, 0.0, 50p, 50p);
    V(c629) <+ transition((code_tot > 629) ? 0.8 : 0.0, 0.0, 50p, 50p);
    V(c630) <+ transition((code_tot > 630) ? 0.8 : 0.0, 0.0, 50p, 50p);
    V(c631) <+ transition((code_tot > 631) ? 0.8 : 0.0, 0.0, 50p, 50p);
    V(c632) <+ transition((code_tot > 632) ? 0.8 : 0.0, 0.0, 50p, 50p);
    V(c633) <+ transition((code_tot > 633) ? 0.8 : 0.0, 0.0, 50p, 50p);
    V(c634) <+ transition((code_tot > 634) ? 0.8 : 0.0, 0.0, 50p, 50p);
    V(c635) <+ transition((code_tot > 635) ? 0.8 : 0.0, 0.0, 50p, 50p);
    V(c636) <+ transition((code_tot > 636) ? 0.8 : 0.0, 0.0, 50p, 50p);
    V(c637) <+ transition((code_tot > 637) ? 0.8 : 0.0, 0.0, 50p, 50p);
    V(c638) <+ transition((code_tot > 638) ? 0.8 : 0.0, 0.0, 50p, 50p);
    V(c639) <+ transition((code_tot > 639) ? 0.8 : 0.0, 0.0, 50p, 50p);
    V(c640) <+ transition((code_tot > 640) ? 0.8 : 0.0, 0.0, 50p, 50p);
    V(c641) <+ transition((code_tot > 641) ? 0.8 : 0.0, 0.0, 50p, 50p);
    V(c642) <+ transition((code_tot > 642) ? 0.8 : 0.0, 0.0, 50p, 50p);
    V(c643) <+ transition((code_tot > 643) ? 0.8 : 0.0, 0.0, 50p, 50p);
    V(c644) <+ transition((code_tot > 644) ? 0.8 : 0.0, 0.0, 50p, 50p);
    V(c645) <+ transition((code_tot > 645) ? 0.8 : 0.0, 0.0, 50p, 50p);
    V(c646) <+ transition((code_tot > 646) ? 0.8 : 0.0, 0.0, 50p, 50p);
    V(c647) <+ transition((code_tot > 647) ? 0.8 : 0.0, 0.0, 50p, 50p);
    V(c648) <+ transition((code_tot > 648) ? 0.8 : 0.0, 0.0, 50p, 50p);
    V(c649) <+ transition((code_tot > 649) ? 0.8 : 0.0, 0.0, 50p, 50p);
    V(c650) <+ transition((code_tot > 650) ? 0.8 : 0.0, 0.0, 50p, 50p);
    V(c651) <+ transition((code_tot > 651) ? 0.8 : 0.0, 0.0, 50p, 50p);
    V(c652) <+ transition((code_tot > 652) ? 0.8 : 0.0, 0.0, 50p, 50p);
    V(c653) <+ transition((code_tot > 653) ? 0.8 : 0.0, 0.0, 50p, 50p);
    V(c654) <+ transition((code_tot > 654) ? 0.8 : 0.0, 0.0, 50p, 50p);
    V(c655) <+ transition((code_tot > 655) ? 0.8 : 0.0, 0.0, 50p, 50p);
    V(c656) <+ transition((code_tot > 656) ? 0.8 : 0.0, 0.0, 50p, 50p);
    V(c657) <+ transition((code_tot > 657) ? 0.8 : 0.0, 0.0, 50p, 50p);
    V(c658) <+ transition((code_tot > 658) ? 0.8 : 0.0, 0.0, 50p, 50p);
    V(c659) <+ transition((code_tot > 659) ? 0.8 : 0.0, 0.0, 50p, 50p);
    V(c660) <+ transition((code_tot > 660) ? 0.8 : 0.0, 0.0, 50p, 50p);
    V(c661) <+ transition((code_tot > 661) ? 0.8 : 0.0, 0.0, 50p, 50p);
    V(c662) <+ transition((code_tot > 662) ? 0.8 : 0.0, 0.0, 50p, 50p);
    V(c663) <+ transition((code_tot > 663) ? 0.8 : 0.0, 0.0, 50p, 50p);
    V(c664) <+ transition((code_tot > 664) ? 0.8 : 0.0, 0.0, 50p, 50p);
    V(c665) <+ transition((code_tot > 665) ? 0.8 : 0.0, 0.0, 50p, 50p);
    V(c666) <+ transition((code_tot > 666) ? 0.8 : 0.0, 0.0, 50p, 50p);
    V(c667) <+ transition((code_tot > 667) ? 0.8 : 0.0, 0.0, 50p, 50p);
    V(c668) <+ transition((code_tot > 668) ? 0.8 : 0.0, 0.0, 50p, 50p);
    V(c669) <+ transition((code_tot > 669) ? 0.8 : 0.0, 0.0, 50p, 50p);
    V(c670) <+ transition((code_tot > 670) ? 0.8 : 0.0, 0.0, 50p, 50p);
    V(c671) <+ transition((code_tot > 671) ? 0.8 : 0.0, 0.0, 50p, 50p);
    V(c672) <+ transition((code_tot > 672) ? 0.8 : 0.0, 0.0, 50p, 50p);
    V(c673) <+ transition((code_tot > 673) ? 0.8 : 0.0, 0.0, 50p, 50p);
    V(c674) <+ transition((code_tot > 674) ? 0.8 : 0.0, 0.0, 50p, 50p);
    V(c675) <+ transition((code_tot > 675) ? 0.8 : 0.0, 0.0, 50p, 50p);
    V(c676) <+ transition((code_tot > 676) ? 0.8 : 0.0, 0.0, 50p, 50p);
    V(c677) <+ transition((code_tot > 677) ? 0.8 : 0.0, 0.0, 50p, 50p);
    V(c678) <+ transition((code_tot > 678) ? 0.8 : 0.0, 0.0, 50p, 50p);
    V(c679) <+ transition((code_tot > 679) ? 0.8 : 0.0, 0.0, 50p, 50p);
    V(c680) <+ transition((code_tot > 680) ? 0.8 : 0.0, 0.0, 50p, 50p);
    V(c681) <+ transition((code_tot > 681) ? 0.8 : 0.0, 0.0, 50p, 50p);
    V(c682) <+ transition((code_tot > 682) ? 0.8 : 0.0, 0.0, 50p, 50p);
    V(c683) <+ transition((code_tot > 683) ? 0.8 : 0.0, 0.0, 50p, 50p);
    V(c684) <+ transition((code_tot > 684) ? 0.8 : 0.0, 0.0, 50p, 50p);
    V(c685) <+ transition((code_tot > 685) ? 0.8 : 0.0, 0.0, 50p, 50p);
    V(c686) <+ transition((code_tot > 686) ? 0.8 : 0.0, 0.0, 50p, 50p);
    V(c687) <+ transition((code_tot > 687) ? 0.8 : 0.0, 0.0, 50p, 50p);
    V(c688) <+ transition((code_tot > 688) ? 0.8 : 0.0, 0.0, 50p, 50p);
    V(c689) <+ transition((code_tot > 689) ? 0.8 : 0.0, 0.0, 50p, 50p);
    V(c690) <+ transition((code_tot > 690) ? 0.8 : 0.0, 0.0, 50p, 50p);
    V(c691) <+ transition((code_tot > 691) ? 0.8 : 0.0, 0.0, 50p, 50p);
    V(c692) <+ transition((code_tot > 692) ? 0.8 : 0.0, 0.0, 50p, 50p);
    V(c693) <+ transition((code_tot > 693) ? 0.8 : 0.0, 0.0, 50p, 50p);
    V(c694) <+ transition((code_tot > 694) ? 0.8 : 0.0, 0.0, 50p, 50p);
    V(c695) <+ transition((code_tot > 695) ? 0.8 : 0.0, 0.0, 50p, 50p);
    V(c696) <+ transition((code_tot > 696) ? 0.8 : 0.0, 0.0, 50p, 50p);
    V(c697) <+ transition((code_tot > 697) ? 0.8 : 0.0, 0.0, 50p, 50p);
    V(c698) <+ transition((code_tot > 698) ? 0.8 : 0.0, 0.0, 50p, 50p);
    V(c699) <+ transition((code_tot > 699) ? 0.8 : 0.0, 0.0, 50p, 50p);
    V(c700) <+ transition((code_tot > 700) ? 0.8 : 0.0, 0.0, 50p, 50p);
    V(c701) <+ transition((code_tot > 701) ? 0.8 : 0.0, 0.0, 50p, 50p);
    V(c702) <+ transition((code_tot > 702) ? 0.8 : 0.0, 0.0, 50p, 50p);
    V(c703) <+ transition((code_tot > 703) ? 0.8 : 0.0, 0.0, 50p, 50p);
    V(c704) <+ transition((code_tot > 704) ? 0.8 : 0.0, 0.0, 50p, 50p);
    V(c705) <+ transition((code_tot > 705) ? 0.8 : 0.0, 0.0, 50p, 50p);
    V(c706) <+ transition((code_tot > 706) ? 0.8 : 0.0, 0.0, 50p, 50p);
    V(c707) <+ transition((code_tot > 707) ? 0.8 : 0.0, 0.0, 50p, 50p);
    V(c708) <+ transition((code_tot > 708) ? 0.8 : 0.0, 0.0, 50p, 50p);
    V(c709) <+ transition((code_tot > 709) ? 0.8 : 0.0, 0.0, 50p, 50p);
    V(c710) <+ transition((code_tot > 710) ? 0.8 : 0.0, 0.0, 50p, 50p);
    V(c711) <+ transition((code_tot > 711) ? 0.8 : 0.0, 0.0, 50p, 50p);
    V(c712) <+ transition((code_tot > 712) ? 0.8 : 0.0, 0.0, 50p, 50p);
    V(c713) <+ transition((code_tot > 713) ? 0.8 : 0.0, 0.0, 50p, 50p);
    V(c714) <+ transition((code_tot > 714) ? 0.8 : 0.0, 0.0, 50p, 50p);
    V(c715) <+ transition((code_tot > 715) ? 0.8 : 0.0, 0.0, 50p, 50p);
    V(c716) <+ transition((code_tot > 716) ? 0.8 : 0.0, 0.0, 50p, 50p);
    V(c717) <+ transition((code_tot > 717) ? 0.8 : 0.0, 0.0, 50p, 50p);
    V(c718) <+ transition((code_tot > 718) ? 0.8 : 0.0, 0.0, 50p, 50p);
    V(c719) <+ transition((code_tot > 719) ? 0.8 : 0.0, 0.0, 50p, 50p);
    V(c720) <+ transition((code_tot > 720) ? 0.8 : 0.0, 0.0, 50p, 50p);
    V(c721) <+ transition((code_tot > 721) ? 0.8 : 0.0, 0.0, 50p, 50p);
    V(c722) <+ transition((code_tot > 722) ? 0.8 : 0.0, 0.0, 50p, 50p);
    V(c723) <+ transition((code_tot > 723) ? 0.8 : 0.0, 0.0, 50p, 50p);
    V(c724) <+ transition((code_tot > 724) ? 0.8 : 0.0, 0.0, 50p, 50p);
    V(c725) <+ transition((code_tot > 725) ? 0.8 : 0.0, 0.0, 50p, 50p);
    V(c726) <+ transition((code_tot > 726) ? 0.8 : 0.0, 0.0, 50p, 50p);
    V(c727) <+ transition((code_tot > 727) ? 0.8 : 0.0, 0.0, 50p, 50p);
    V(c728) <+ transition((code_tot > 728) ? 0.8 : 0.0, 0.0, 50p, 50p);
    V(c729) <+ transition((code_tot > 729) ? 0.8 : 0.0, 0.0, 50p, 50p);
    V(c730) <+ transition((code_tot > 730) ? 0.8 : 0.0, 0.0, 50p, 50p);
    V(c731) <+ transition((code_tot > 731) ? 0.8 : 0.0, 0.0, 50p, 50p);
    V(c732) <+ transition((code_tot > 732) ? 0.8 : 0.0, 0.0, 50p, 50p);
    V(c733) <+ transition((code_tot > 733) ? 0.8 : 0.0, 0.0, 50p, 50p);
    V(c734) <+ transition((code_tot > 734) ? 0.8 : 0.0, 0.0, 50p, 50p);
    V(c735) <+ transition((code_tot > 735) ? 0.8 : 0.0, 0.0, 50p, 50p);
    V(c736) <+ transition((code_tot > 736) ? 0.8 : 0.0, 0.0, 50p, 50p);
    V(c737) <+ transition((code_tot > 737) ? 0.8 : 0.0, 0.0, 50p, 50p);
    V(c738) <+ transition((code_tot > 738) ? 0.8 : 0.0, 0.0, 50p, 50p);
    V(c739) <+ transition((code_tot > 739) ? 0.8 : 0.0, 0.0, 50p, 50p);
    V(c740) <+ transition((code_tot > 740) ? 0.8 : 0.0, 0.0, 50p, 50p);
    V(c741) <+ transition((code_tot > 741) ? 0.8 : 0.0, 0.0, 50p, 50p);
    V(c742) <+ transition((code_tot > 742) ? 0.8 : 0.0, 0.0, 50p, 50p);
    V(c743) <+ transition((code_tot > 743) ? 0.8 : 0.0, 0.0, 50p, 50p);
    V(c744) <+ transition((code_tot > 744) ? 0.8 : 0.0, 0.0, 50p, 50p);
    V(c745) <+ transition((code_tot > 745) ? 0.8 : 0.0, 0.0, 50p, 50p);
    V(c746) <+ transition((code_tot > 746) ? 0.8 : 0.0, 0.0, 50p, 50p);
    V(c747) <+ transition((code_tot > 747) ? 0.8 : 0.0, 0.0, 50p, 50p);
    V(c748) <+ transition((code_tot > 748) ? 0.8 : 0.0, 0.0, 50p, 50p);
    V(c749) <+ transition((code_tot > 749) ? 0.8 : 0.0, 0.0, 50p, 50p);
    V(c750) <+ transition((code_tot > 750) ? 0.8 : 0.0, 0.0, 50p, 50p);
    V(c751) <+ transition((code_tot > 751) ? 0.8 : 0.0, 0.0, 50p, 50p);
    V(c752) <+ transition((code_tot > 752) ? 0.8 : 0.0, 0.0, 50p, 50p);
    V(c753) <+ transition((code_tot > 753) ? 0.8 : 0.0, 0.0, 50p, 50p);
    V(c754) <+ transition((code_tot > 754) ? 0.8 : 0.0, 0.0, 50p, 50p);
    V(c755) <+ transition((code_tot > 755) ? 0.8 : 0.0, 0.0, 50p, 50p);
    V(c756) <+ transition((code_tot > 756) ? 0.8 : 0.0, 0.0, 50p, 50p);
    V(c757) <+ transition((code_tot > 757) ? 0.8 : 0.0, 0.0, 50p, 50p);
    V(c758) <+ transition((code_tot > 758) ? 0.8 : 0.0, 0.0, 50p, 50p);
    V(c759) <+ transition((code_tot > 759) ? 0.8 : 0.0, 0.0, 50p, 50p);
    V(c760) <+ transition((code_tot > 760) ? 0.8 : 0.0, 0.0, 50p, 50p);
    V(c761) <+ transition((code_tot > 761) ? 0.8 : 0.0, 0.0, 50p, 50p);
    V(c762) <+ transition((code_tot > 762) ? 0.8 : 0.0, 0.0, 50p, 50p);
    V(c763) <+ transition((code_tot > 763) ? 0.8 : 0.0, 0.0, 50p, 50p);
    V(c764) <+ transition((code_tot > 764) ? 0.8 : 0.0, 0.0, 50p, 50p);
    V(c765) <+ transition((code_tot > 765) ? 0.8 : 0.0, 0.0, 50p, 50p);
    V(c766) <+ transition((code_tot > 766) ? 0.8 : 0.0, 0.0, 50p, 50p);
    V(c767) <+ transition((code_tot > 767) ? 0.8 : 0.0, 0.0, 50p, 50p);
    V(c768) <+ transition((code_tot > 768) ? 0.8 : 0.0, 0.0, 50p, 50p);
    V(c769) <+ transition((code_tot > 769) ? 0.8 : 0.0, 0.0, 50p, 50p);
    V(c770) <+ transition((code_tot > 770) ? 0.8 : 0.0, 0.0, 50p, 50p);
    V(c771) <+ transition((code_tot > 771) ? 0.8 : 0.0, 0.0, 50p, 50p);
    V(c772) <+ transition((code_tot > 772) ? 0.8 : 0.0, 0.0, 50p, 50p);
    V(c773) <+ transition((code_tot > 773) ? 0.8 : 0.0, 0.0, 50p, 50p);
    V(c774) <+ transition((code_tot > 774) ? 0.8 : 0.0, 0.0, 50p, 50p);
    V(c775) <+ transition((code_tot > 775) ? 0.8 : 0.0, 0.0, 50p, 50p);
    V(c776) <+ transition((code_tot > 776) ? 0.8 : 0.0, 0.0, 50p, 50p);
    V(c777) <+ transition((code_tot > 777) ? 0.8 : 0.0, 0.0, 50p, 50p);
    V(c778) <+ transition((code_tot > 778) ? 0.8 : 0.0, 0.0, 50p, 50p);
    V(c779) <+ transition((code_tot > 779) ? 0.8 : 0.0, 0.0, 50p, 50p);
    V(c780) <+ transition((code_tot > 780) ? 0.8 : 0.0, 0.0, 50p, 50p);
    V(c781) <+ transition((code_tot > 781) ? 0.8 : 0.0, 0.0, 50p, 50p);
    V(c782) <+ transition((code_tot > 782) ? 0.8 : 0.0, 0.0, 50p, 50p);
    V(c783) <+ transition((code_tot > 783) ? 0.8 : 0.0, 0.0, 50p, 50p);
    V(c784) <+ transition((code_tot > 784) ? 0.8 : 0.0, 0.0, 50p, 50p);
    V(c785) <+ transition((code_tot > 785) ? 0.8 : 0.0, 0.0, 50p, 50p);
    V(c786) <+ transition((code_tot > 786) ? 0.8 : 0.0, 0.0, 50p, 50p);
    V(c787) <+ transition((code_tot > 787) ? 0.8 : 0.0, 0.0, 50p, 50p);
    V(c788) <+ transition((code_tot > 788) ? 0.8 : 0.0, 0.0, 50p, 50p);
    V(c789) <+ transition((code_tot > 789) ? 0.8 : 0.0, 0.0, 50p, 50p);
    V(c790) <+ transition((code_tot > 790) ? 0.8 : 0.0, 0.0, 50p, 50p);
    V(c791) <+ transition((code_tot > 791) ? 0.8 : 0.0, 0.0, 50p, 50p);
    V(c792) <+ transition((code_tot > 792) ? 0.8 : 0.0, 0.0, 50p, 50p);
    V(c793) <+ transition((code_tot > 793) ? 0.8 : 0.0, 0.0, 50p, 50p);
    V(c794) <+ transition((code_tot > 794) ? 0.8 : 0.0, 0.0, 50p, 50p);
    V(c795) <+ transition((code_tot > 795) ? 0.8 : 0.0, 0.0, 50p, 50p);
    V(c796) <+ transition((code_tot > 796) ? 0.8 : 0.0, 0.0, 50p, 50p);
    V(c797) <+ transition((code_tot > 797) ? 0.8 : 0.0, 0.0, 50p, 50p);
    V(c798) <+ transition((code_tot > 798) ? 0.8 : 0.0, 0.0, 50p, 50p);
    V(c799) <+ transition((code_tot > 799) ? 0.8 : 0.0, 0.0, 50p, 50p);
    V(c800) <+ transition((code_tot > 800) ? 0.8 : 0.0, 0.0, 50p, 50p);
    V(c801) <+ transition((code_tot > 801) ? 0.8 : 0.0, 0.0, 50p, 50p);
    V(c802) <+ transition((code_tot > 802) ? 0.8 : 0.0, 0.0, 50p, 50p);
    V(c803) <+ transition((code_tot > 803) ? 0.8 : 0.0, 0.0, 50p, 50p);
    V(c804) <+ transition((code_tot > 804) ? 0.8 : 0.0, 0.0, 50p, 50p);
    V(c805) <+ transition((code_tot > 805) ? 0.8 : 0.0, 0.0, 50p, 50p);
    V(c806) <+ transition((code_tot > 806) ? 0.8 : 0.0, 0.0, 50p, 50p);
    V(c807) <+ transition((code_tot > 807) ? 0.8 : 0.0, 0.0, 50p, 50p);
    V(c808) <+ transition((code_tot > 808) ? 0.8 : 0.0, 0.0, 50p, 50p);
    V(c809) <+ transition((code_tot > 809) ? 0.8 : 0.0, 0.0, 50p, 50p);
    V(c810) <+ transition((code_tot > 810) ? 0.8 : 0.0, 0.0, 50p, 50p);
    V(c811) <+ transition((code_tot > 811) ? 0.8 : 0.0, 0.0, 50p, 50p);
    V(c812) <+ transition((code_tot > 812) ? 0.8 : 0.0, 0.0, 50p, 50p);
    V(c813) <+ transition((code_tot > 813) ? 0.8 : 0.0, 0.0, 50p, 50p);
    V(c814) <+ transition((code_tot > 814) ? 0.8 : 0.0, 0.0, 50p, 50p);
    V(c815) <+ transition((code_tot > 815) ? 0.8 : 0.0, 0.0, 50p, 50p);
    V(c816) <+ transition((code_tot > 816) ? 0.8 : 0.0, 0.0, 50p, 50p);
    V(c817) <+ transition((code_tot > 817) ? 0.8 : 0.0, 0.0, 50p, 50p);
    V(c818) <+ transition((code_tot > 818) ? 0.8 : 0.0, 0.0, 50p, 50p);
    V(c819) <+ transition((code_tot > 819) ? 0.8 : 0.0, 0.0, 50p, 50p);
    V(c820) <+ transition((code_tot > 820) ? 0.8 : 0.0, 0.0, 50p, 50p);
    V(c821) <+ transition((code_tot > 821) ? 0.8 : 0.0, 0.0, 50p, 50p);
    V(c822) <+ transition((code_tot > 822) ? 0.8 : 0.0, 0.0, 50p, 50p);
    V(c823) <+ transition((code_tot > 823) ? 0.8 : 0.0, 0.0, 50p, 50p);
    V(c824) <+ transition((code_tot > 824) ? 0.8 : 0.0, 0.0, 50p, 50p);
    V(c825) <+ transition((code_tot > 825) ? 0.8 : 0.0, 0.0, 50p, 50p);
    V(c826) <+ transition((code_tot > 826) ? 0.8 : 0.0, 0.0, 50p, 50p);
    V(c827) <+ transition((code_tot > 827) ? 0.8 : 0.0, 0.0, 50p, 50p);
    V(c828) <+ transition((code_tot > 828) ? 0.8 : 0.0, 0.0, 50p, 50p);
    V(c829) <+ transition((code_tot > 829) ? 0.8 : 0.0, 0.0, 50p, 50p);
    V(c830) <+ transition((code_tot > 830) ? 0.8 : 0.0, 0.0, 50p, 50p);
    V(c831) <+ transition((code_tot > 831) ? 0.8 : 0.0, 0.0, 50p, 50p);
    V(c832) <+ transition((code_tot > 832) ? 0.8 : 0.0, 0.0, 50p, 50p);
    V(c833) <+ transition((code_tot > 833) ? 0.8 : 0.0, 0.0, 50p, 50p);
    V(c834) <+ transition((code_tot > 834) ? 0.8 : 0.0, 0.0, 50p, 50p);
    V(c835) <+ transition((code_tot > 835) ? 0.8 : 0.0, 0.0, 50p, 50p);
    V(c836) <+ transition((code_tot > 836) ? 0.8 : 0.0, 0.0, 50p, 50p);
    V(c837) <+ transition((code_tot > 837) ? 0.8 : 0.0, 0.0, 50p, 50p);
    V(c838) <+ transition((code_tot > 838) ? 0.8 : 0.0, 0.0, 50p, 50p);
    V(c839) <+ transition((code_tot > 839) ? 0.8 : 0.0, 0.0, 50p, 50p);
    V(c840) <+ transition((code_tot > 840) ? 0.8 : 0.0, 0.0, 50p, 50p);
    V(c841) <+ transition((code_tot > 841) ? 0.8 : 0.0, 0.0, 50p, 50p);
    V(c842) <+ transition((code_tot > 842) ? 0.8 : 0.0, 0.0, 50p, 50p);
    V(c843) <+ transition((code_tot > 843) ? 0.8 : 0.0, 0.0, 50p, 50p);
    V(c844) <+ transition((code_tot > 844) ? 0.8 : 0.0, 0.0, 50p, 50p);
    V(c845) <+ transition((code_tot > 845) ? 0.8 : 0.0, 0.0, 50p, 50p);
    V(c846) <+ transition((code_tot > 846) ? 0.8 : 0.0, 0.0, 50p, 50p);
    V(c847) <+ transition((code_tot > 847) ? 0.8 : 0.0, 0.0, 50p, 50p);
    V(c848) <+ transition((code_tot > 848) ? 0.8 : 0.0, 0.0, 50p, 50p);
    V(c849) <+ transition((code_tot > 849) ? 0.8 : 0.0, 0.0, 50p, 50p);
    V(c850) <+ transition((code_tot > 850) ? 0.8 : 0.0, 0.0, 50p, 50p);
    V(c851) <+ transition((code_tot > 851) ? 0.8 : 0.0, 0.0, 50p, 50p);
    V(c852) <+ transition((code_tot > 852) ? 0.8 : 0.0, 0.0, 50p, 50p);
    V(c853) <+ transition((code_tot > 853) ? 0.8 : 0.0, 0.0, 50p, 50p);
    V(c854) <+ transition((code_tot > 854) ? 0.8 : 0.0, 0.0, 50p, 50p);
    V(c855) <+ transition((code_tot > 855) ? 0.8 : 0.0, 0.0, 50p, 50p);
    V(c856) <+ transition((code_tot > 856) ? 0.8 : 0.0, 0.0, 50p, 50p);
    V(c857) <+ transition((code_tot > 857) ? 0.8 : 0.0, 0.0, 50p, 50p);
    V(c858) <+ transition((code_tot > 858) ? 0.8 : 0.0, 0.0, 50p, 50p);
    V(c859) <+ transition((code_tot > 859) ? 0.8 : 0.0, 0.0, 50p, 50p);
    V(c860) <+ transition((code_tot > 860) ? 0.8 : 0.0, 0.0, 50p, 50p);
    V(c861) <+ transition((code_tot > 861) ? 0.8 : 0.0, 0.0, 50p, 50p);
    V(c862) <+ transition((code_tot > 862) ? 0.8 : 0.0, 0.0, 50p, 50p);
    V(c863) <+ transition((code_tot > 863) ? 0.8 : 0.0, 0.0, 50p, 50p);
    V(c864) <+ transition((code_tot > 864) ? 0.8 : 0.0, 0.0, 50p, 50p);
    V(c865) <+ transition((code_tot > 865) ? 0.8 : 0.0, 0.0, 50p, 50p);
    V(c866) <+ transition((code_tot > 866) ? 0.8 : 0.0, 0.0, 50p, 50p);
    V(c867) <+ transition((code_tot > 867) ? 0.8 : 0.0, 0.0, 50p, 50p);
    V(c868) <+ transition((code_tot > 868) ? 0.8 : 0.0, 0.0, 50p, 50p);
    V(c869) <+ transition((code_tot > 869) ? 0.8 : 0.0, 0.0, 50p, 50p);
    V(c870) <+ transition((code_tot > 870) ? 0.8 : 0.0, 0.0, 50p, 50p);
    V(c871) <+ transition((code_tot > 871) ? 0.8 : 0.0, 0.0, 50p, 50p);
    V(c872) <+ transition((code_tot > 872) ? 0.8 : 0.0, 0.0, 50p, 50p);
    V(c873) <+ transition((code_tot > 873) ? 0.8 : 0.0, 0.0, 50p, 50p);
    V(c874) <+ transition((code_tot > 874) ? 0.8 : 0.0, 0.0, 50p, 50p);
    V(c875) <+ transition((code_tot > 875) ? 0.8 : 0.0, 0.0, 50p, 50p);
    V(c876) <+ transition((code_tot > 876) ? 0.8 : 0.0, 0.0, 50p, 50p);
    V(c877) <+ transition((code_tot > 877) ? 0.8 : 0.0, 0.0, 50p, 50p);
    V(c878) <+ transition((code_tot > 878) ? 0.8 : 0.0, 0.0, 50p, 50p);
    V(c879) <+ transition((code_tot > 879) ? 0.8 : 0.0, 0.0, 50p, 50p);
    V(c880) <+ transition((code_tot > 880) ? 0.8 : 0.0, 0.0, 50p, 50p);
    V(c881) <+ transition((code_tot > 881) ? 0.8 : 0.0, 0.0, 50p, 50p);
    V(c882) <+ transition((code_tot > 882) ? 0.8 : 0.0, 0.0, 50p, 50p);
    V(c883) <+ transition((code_tot > 883) ? 0.8 : 0.0, 0.0, 50p, 50p);
    V(c884) <+ transition((code_tot > 884) ? 0.8 : 0.0, 0.0, 50p, 50p);
    V(c885) <+ transition((code_tot > 885) ? 0.8 : 0.0, 0.0, 50p, 50p);
    V(c886) <+ transition((code_tot > 886) ? 0.8 : 0.0, 0.0, 50p, 50p);
    V(c887) <+ transition((code_tot > 887) ? 0.8 : 0.0, 0.0, 50p, 50p);
    V(c888) <+ transition((code_tot > 888) ? 0.8 : 0.0, 0.0, 50p, 50p);
    V(c889) <+ transition((code_tot > 889) ? 0.8 : 0.0, 0.0, 50p, 50p);
    V(c890) <+ transition((code_tot > 890) ? 0.8 : 0.0, 0.0, 50p, 50p);
    V(c891) <+ transition((code_tot > 891) ? 0.8 : 0.0, 0.0, 50p, 50p);
    V(c892) <+ transition((code_tot > 892) ? 0.8 : 0.0, 0.0, 50p, 50p);
    V(c893) <+ transition((code_tot > 893) ? 0.8 : 0.0, 0.0, 50p, 50p);
    V(c894) <+ transition((code_tot > 894) ? 0.8 : 0.0, 0.0, 50p, 50p);
    V(c895) <+ transition((code_tot > 895) ? 0.8 : 0.0, 0.0, 50p, 50p);
    V(c896) <+ transition((code_tot > 896) ? 0.8 : 0.0, 0.0, 50p, 50p);
    V(c897) <+ transition((code_tot > 897) ? 0.8 : 0.0, 0.0, 50p, 50p);
    V(c898) <+ transition((code_tot > 898) ? 0.8 : 0.0, 0.0, 50p, 50p);
    V(c899) <+ transition((code_tot > 899) ? 0.8 : 0.0, 0.0, 50p, 50p);
    V(c900) <+ transition((code_tot > 900) ? 0.8 : 0.0, 0.0, 50p, 50p);
    V(c901) <+ transition((code_tot > 901) ? 0.8 : 0.0, 0.0, 50p, 50p);
    V(c902) <+ transition((code_tot > 902) ? 0.8 : 0.0, 0.0, 50p, 50p);
    V(c903) <+ transition((code_tot > 903) ? 0.8 : 0.0, 0.0, 50p, 50p);
    V(c904) <+ transition((code_tot > 904) ? 0.8 : 0.0, 0.0, 50p, 50p);
    V(c905) <+ transition((code_tot > 905) ? 0.8 : 0.0, 0.0, 50p, 50p);
    V(c906) <+ transition((code_tot > 906) ? 0.8 : 0.0, 0.0, 50p, 50p);
    V(c907) <+ transition((code_tot > 907) ? 0.8 : 0.0, 0.0, 50p, 50p);
    V(c908) <+ transition((code_tot > 908) ? 0.8 : 0.0, 0.0, 50p, 50p);
    V(c909) <+ transition((code_tot > 909) ? 0.8 : 0.0, 0.0, 50p, 50p);
    V(c910) <+ transition((code_tot > 910) ? 0.8 : 0.0, 0.0, 50p, 50p);
    V(c911) <+ transition((code_tot > 911) ? 0.8 : 0.0, 0.0, 50p, 50p);
    V(c912) <+ transition((code_tot > 912) ? 0.8 : 0.0, 0.0, 50p, 50p);
    V(c913) <+ transition((code_tot > 913) ? 0.8 : 0.0, 0.0, 50p, 50p);
    V(c914) <+ transition((code_tot > 914) ? 0.8 : 0.0, 0.0, 50p, 50p);
    V(c915) <+ transition((code_tot > 915) ? 0.8 : 0.0, 0.0, 50p, 50p);
    V(c916) <+ transition((code_tot > 916) ? 0.8 : 0.0, 0.0, 50p, 50p);
    V(c917) <+ transition((code_tot > 917) ? 0.8 : 0.0, 0.0, 50p, 50p);
    V(c918) <+ transition((code_tot > 918) ? 0.8 : 0.0, 0.0, 50p, 50p);
    V(c919) <+ transition((code_tot > 919) ? 0.8 : 0.0, 0.0, 50p, 50p);
    V(c920) <+ transition((code_tot > 920) ? 0.8 : 0.0, 0.0, 50p, 50p);
    V(c921) <+ transition((code_tot > 921) ? 0.8 : 0.0, 0.0, 50p, 50p);
    V(c922) <+ transition((code_tot > 922) ? 0.8 : 0.0, 0.0, 50p, 50p);
    V(c923) <+ transition((code_tot > 923) ? 0.8 : 0.0, 0.0, 50p, 50p);
    V(c924) <+ transition((code_tot > 924) ? 0.8 : 0.0, 0.0, 50p, 50p);
    V(c925) <+ transition((code_tot > 925) ? 0.8 : 0.0, 0.0, 50p, 50p);
    V(c926) <+ transition((code_tot > 926) ? 0.8 : 0.0, 0.0, 50p, 50p);
    V(c927) <+ transition((code_tot > 927) ? 0.8 : 0.0, 0.0, 50p, 50p);
    V(c928) <+ transition((code_tot > 928) ? 0.8 : 0.0, 0.0, 50p, 50p);
    V(c929) <+ transition((code_tot > 929) ? 0.8 : 0.0, 0.0, 50p, 50p);
    V(c930) <+ transition((code_tot > 930) ? 0.8 : 0.0, 0.0, 50p, 50p);
    V(c931) <+ transition((code_tot > 931) ? 0.8 : 0.0, 0.0, 50p, 50p);
    V(c932) <+ transition((code_tot > 932) ? 0.8 : 0.0, 0.0, 50p, 50p);
    V(c933) <+ transition((code_tot > 933) ? 0.8 : 0.0, 0.0, 50p, 50p);
    V(c934) <+ transition((code_tot > 934) ? 0.8 : 0.0, 0.0, 50p, 50p);
    V(c935) <+ transition((code_tot > 935) ? 0.8 : 0.0, 0.0, 50p, 50p);
    V(c936) <+ transition((code_tot > 936) ? 0.8 : 0.0, 0.0, 50p, 50p);
    V(c937) <+ transition((code_tot > 937) ? 0.8 : 0.0, 0.0, 50p, 50p);
    V(c938) <+ transition((code_tot > 938) ? 0.8 : 0.0, 0.0, 50p, 50p);
    V(c939) <+ transition((code_tot > 939) ? 0.8 : 0.0, 0.0, 50p, 50p);
    V(c940) <+ transition((code_tot > 940) ? 0.8 : 0.0, 0.0, 50p, 50p);
    V(c941) <+ transition((code_tot > 941) ? 0.8 : 0.0, 0.0, 50p, 50p);
    V(c942) <+ transition((code_tot > 942) ? 0.8 : 0.0, 0.0, 50p, 50p);
    V(c943) <+ transition((code_tot > 943) ? 0.8 : 0.0, 0.0, 50p, 50p);
    V(c944) <+ transition((code_tot > 944) ? 0.8 : 0.0, 0.0, 50p, 50p);
    V(c945) <+ transition((code_tot > 945) ? 0.8 : 0.0, 0.0, 50p, 50p);
    V(c946) <+ transition((code_tot > 946) ? 0.8 : 0.0, 0.0, 50p, 50p);
    V(c947) <+ transition((code_tot > 947) ? 0.8 : 0.0, 0.0, 50p, 50p);
    V(c948) <+ transition((code_tot > 948) ? 0.8 : 0.0, 0.0, 50p, 50p);
    V(c949) <+ transition((code_tot > 949) ? 0.8 : 0.0, 0.0, 50p, 50p);
    V(c950) <+ transition((code_tot > 950) ? 0.8 : 0.0, 0.0, 50p, 50p);
    V(c951) <+ transition((code_tot > 951) ? 0.8 : 0.0, 0.0, 50p, 50p);
    V(c952) <+ transition((code_tot > 952) ? 0.8 : 0.0, 0.0, 50p, 50p);
    V(c953) <+ transition((code_tot > 953) ? 0.8 : 0.0, 0.0, 50p, 50p);
    V(c954) <+ transition((code_tot > 954) ? 0.8 : 0.0, 0.0, 50p, 50p);
    V(c955) <+ transition((code_tot > 955) ? 0.8 : 0.0, 0.0, 50p, 50p);
    V(c956) <+ transition((code_tot > 956) ? 0.8 : 0.0, 0.0, 50p, 50p);
    V(c957) <+ transition((code_tot > 957) ? 0.8 : 0.0, 0.0, 50p, 50p);
    V(c958) <+ transition((code_tot > 958) ? 0.8 : 0.0, 0.0, 50p, 50p);
    V(c959) <+ transition((code_tot > 959) ? 0.8 : 0.0, 0.0, 50p, 50p);
    V(c960) <+ transition((code_tot > 960) ? 0.8 : 0.0, 0.0, 50p, 50p);
    V(c961) <+ transition((code_tot > 961) ? 0.8 : 0.0, 0.0, 50p, 50p);
    V(c962) <+ transition((code_tot > 962) ? 0.8 : 0.0, 0.0, 50p, 50p);
    V(c963) <+ transition((code_tot > 963) ? 0.8 : 0.0, 0.0, 50p, 50p);
    V(c964) <+ transition((code_tot > 964) ? 0.8 : 0.0, 0.0, 50p, 50p);
    V(c965) <+ transition((code_tot > 965) ? 0.8 : 0.0, 0.0, 50p, 50p);
    V(c966) <+ transition((code_tot > 966) ? 0.8 : 0.0, 0.0, 50p, 50p);
    V(c967) <+ transition((code_tot > 967) ? 0.8 : 0.0, 0.0, 50p, 50p);
    V(c968) <+ transition((code_tot > 968) ? 0.8 : 0.0, 0.0, 50p, 50p);
    V(c969) <+ transition((code_tot > 969) ? 0.8 : 0.0, 0.0, 50p, 50p);
    V(c970) <+ transition((code_tot > 970) ? 0.8 : 0.0, 0.0, 50p, 50p);
    V(c971) <+ transition((code_tot > 971) ? 0.8 : 0.0, 0.0, 50p, 50p);
    V(c972) <+ transition((code_tot > 972) ? 0.8 : 0.0, 0.0, 50p, 50p);
    V(c973) <+ transition((code_tot > 973) ? 0.8 : 0.0, 0.0, 50p, 50p);
    V(c974) <+ transition((code_tot > 974) ? 0.8 : 0.0, 0.0, 50p, 50p);
    V(c975) <+ transition((code_tot > 975) ? 0.8 : 0.0, 0.0, 50p, 50p);
    V(c976) <+ transition((code_tot > 976) ? 0.8 : 0.0, 0.0, 50p, 50p);
    V(c977) <+ transition((code_tot > 977) ? 0.8 : 0.0, 0.0, 50p, 50p);
    V(c978) <+ transition((code_tot > 978) ? 0.8 : 0.0, 0.0, 50p, 50p);
    V(c979) <+ transition((code_tot > 979) ? 0.8 : 0.0, 0.0, 50p, 50p);
    V(c980) <+ transition((code_tot > 980) ? 0.8 : 0.0, 0.0, 50p, 50p);
    V(c981) <+ transition((code_tot > 981) ? 0.8 : 0.0, 0.0, 50p, 50p);
    V(c982) <+ transition((code_tot > 982) ? 0.8 : 0.0, 0.0, 50p, 50p);
    V(c983) <+ transition((code_tot > 983) ? 0.8 : 0.0, 0.0, 50p, 50p);
    V(c984) <+ transition((code_tot > 984) ? 0.8 : 0.0, 0.0, 50p, 50p);
    V(c985) <+ transition((code_tot > 985) ? 0.8 : 0.0, 0.0, 50p, 50p);
    V(c986) <+ transition((code_tot > 986) ? 0.8 : 0.0, 0.0, 50p, 50p);
    V(c987) <+ transition((code_tot > 987) ? 0.8 : 0.0, 0.0, 50p, 50p);
    V(c988) <+ transition((code_tot > 988) ? 0.8 : 0.0, 0.0, 50p, 50p);
    V(c989) <+ transition((code_tot > 989) ? 0.8 : 0.0, 0.0, 50p, 50p);
    V(c990) <+ transition((code_tot > 990) ? 0.8 : 0.0, 0.0, 50p, 50p);
    V(c991) <+ transition((code_tot > 991) ? 0.8 : 0.0, 0.0, 50p, 50p);
    V(c992) <+ transition((code_tot > 992) ? 0.8 : 0.0, 0.0, 50p, 50p);
    V(c993) <+ transition((code_tot > 993) ? 0.8 : 0.0, 0.0, 50p, 50p);
    V(c994) <+ transition((code_tot > 994) ? 0.8 : 0.0, 0.0, 50p, 50p);
    V(c995) <+ transition((code_tot > 995) ? 0.8 : 0.0, 0.0, 50p, 50p);
    V(c996) <+ transition((code_tot > 996) ? 0.8 : 0.0, 0.0, 50p, 50p);
    V(c997) <+ transition((code_tot > 997) ? 0.8 : 0.0, 0.0, 50p, 50p);
    V(c998) <+ transition((code_tot > 998) ? 0.8 : 0.0, 0.0, 50p, 50p);
    V(c999) <+ transition((code_tot > 999) ? 0.8 : 0.0, 0.0, 50p, 50p);
    V(c1000) <+ transition((code_tot > 1000) ? 0.8 : 0.0, 0.0, 50p, 50p);
    V(c1001) <+ transition((code_tot > 1001) ? 0.8 : 0.0, 0.0, 50p, 50p);
    V(c1002) <+ transition((code_tot > 1002) ? 0.8 : 0.0, 0.0, 50p, 50p);
    V(c1003) <+ transition((code_tot > 1003) ? 0.8 : 0.0, 0.0, 50p, 50p);
    V(c1004) <+ transition((code_tot > 1004) ? 0.8 : 0.0, 0.0, 50p, 50p);
    V(c1005) <+ transition((code_tot > 1005) ? 0.8 : 0.0, 0.0, 50p, 50p);
    V(c1006) <+ transition((code_tot > 1006) ? 0.8 : 0.0, 0.0, 50p, 50p);
    V(c1007) <+ transition((code_tot > 1007) ? 0.8 : 0.0, 0.0, 50p, 50p);
    V(c1008) <+ transition((code_tot > 1008) ? 0.8 : 0.0, 0.0, 50p, 50p);
    V(c1009) <+ transition((code_tot > 1009) ? 0.8 : 0.0, 0.0, 50p, 50p);
    V(c1010) <+ transition((code_tot > 1010) ? 0.8 : 0.0, 0.0, 50p, 50p);
    V(c1011) <+ transition((code_tot > 1011) ? 0.8 : 0.0, 0.0, 50p, 50p);
    V(c1012) <+ transition((code_tot > 1012) ? 0.8 : 0.0, 0.0, 50p, 50p);
    V(c1013) <+ transition((code_tot > 1013) ? 0.8 : 0.0, 0.0, 50p, 50p);
    V(c1014) <+ transition((code_tot > 1014) ? 0.8 : 0.0, 0.0, 50p, 50p);
    V(c1015) <+ transition((code_tot > 1015) ? 0.8 : 0.0, 0.0, 50p, 50p);
    V(c1016) <+ transition((code_tot > 1016) ? 0.8 : 0.0, 0.0, 50p, 50p);
    V(c1017) <+ transition((code_tot > 1017) ? 0.8 : 0.0, 0.0, 50p, 50p);
    V(c1018) <+ transition((code_tot > 1018) ? 0.8 : 0.0, 0.0, 50p, 50p);
    V(c1019) <+ transition((code_tot > 1019) ? 0.8 : 0.0, 0.0, 50p, 50p);
    V(c1020) <+ transition((code_tot > 1020) ? 0.8 : 0.0, 0.0, 50p, 50p);
    V(c1021) <+ transition((code_tot > 1021) ? 0.8 : 0.0, 0.0, 50p, 50p);
    V(c1022) <+ transition((code_tot > 1022) ? 0.8 : 0.0, 0.0, 50p, 50p);
end
endmodule
