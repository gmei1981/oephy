subckt vco_x (VDD VSS VCTRL OUTP OUTN)

MN1 (OUTP OUTN VSS VSS) nch_svt_mac l=16n nfin=2 w=58n multi=1 nf=16 \
        sd=74n sa=90n sb=90n ploda1=16n ploda2=0 ploda3=0 plodb1=16n \
        plodb2=0 plodb3=0 nf_flag=1 smbt=1M smbb=1M dinsaflag=0 ppitch=0 \
        spot=103n spob=103n spotl1=103n spobl1=103n spotl2=103n \
        spobl2=103n spotr1=103n spobr1=103n spotr2=103n spobr2=103n
MN0 (OUTN OUTP VSS VSS) nch_svt_mac l=16n nfin=2 w=58n multi=1 nf=16 \
        sd=74n sa=90n sb=90n ploda1=16n ploda2=0 ploda3=0 plodb1=16n \
        plodb2=0 plodb3=0 nf_flag=1 smbt=1M smbb=1M dinsaflag=0 ppitch=0 \
        spot=103n spob=103n spotl1=103n spobl1=103n spotl2=103n \
        spobl2=103n spotr1=103n spobr1=103n spotr2=103n spobr2=103n
L1 (VDD OUTN) inductor l=2.49n r=2
L0 (VDD OUTP) inductor l=2.49n r=2
CF11 (net08 OUTN VSS) cfmom_wo_p80 dmflag=0 lr=1u multi=1 mxd_flag=0 \
        nr=192 n_mxa=2 shield=2 spm=3 stm=1 vapmod=2 grflag=1 gdis_t=185n \
        gdis_b=185n gdis_l=102n gdis_r=102n
CF10 (net09 OUTN VSS) cfmom_wo_p80 dmflag=0 lr=1u multi=1 mxd_flag=0 \
        nr=192 n_mxa=2 shield=2 spm=3 stm=1 vapmod=2 grflag=1 gdis_t=185n \
        gdis_b=185n gdis_l=102n gdis_r=102n
CF9 (OUTN OUTN VSS) cfmom_wo_p80 dmflag=0 lr=1u multi=1 mxd_flag=0 nr=192 \
        n_mxa=2 shield=2 spm=3 stm=1 vapmod=2 grflag=1 gdis_t=185n \
        gdis_b=185n gdis_l=102n gdis_r=102n
CF8 (net15 OUTN VSS) cfmom_wo_p80 dmflag=0 lr=1u multi=1 mxd_flag=0 nr=192 \
        n_mxa=2 shield=2 spm=3 stm=1 vapmod=2 grflag=1 gdis_t=185n \
        gdis_b=185n gdis_l=102n gdis_r=102n
CF7 (net16 OUTN VSS) cfmom_wo_p80 dmflag=0 lr=1u multi=1 mxd_flag=0 nr=192 \
        n_mxa=2 shield=2 spm=3 stm=1 vapmod=2 grflag=1 gdis_t=185n \
        gdis_b=185n gdis_l=102n gdis_r=102n
CF6 (OUTP OUTN VSS) cfmom_wo_p80 dmflag=0 lr=1u multi=1 mxd_flag=0 nr=192 \
        n_mxa=2 shield=2 spm=3 stm=1 vapmod=2 grflag=1 gdis_t=185n \
        gdis_b=185n gdis_l=102n gdis_r=102n
CF5 (net8 OUTN VSS) cfmom_wo_p80 dmflag=0 lr=1u multi=1 mxd_flag=0 nr=192 \
        n_mxa=2 shield=2 spm=3 stm=1 vapmod=2 grflag=1 gdis_t=185n \
        gdis_b=185n gdis_l=102n gdis_r=102n
CF4 (net9 OUTN VSS) cfmom_wo_p80 dmflag=0 lr=1u multi=1 mxd_flag=0 nr=192 \
        n_mxa=2 shield=2 spm=3 stm=1 vapmod=2 grflag=1 gdis_t=185n \
        gdis_b=185n gdis_l=102n gdis_r=102n
CF3 (net10 OUTN VSS) cfmom_wo_p80 dmflag=0 lr=1u multi=1 mxd_flag=0 nr=192 \
        n_mxa=2 shield=2 spm=3 stm=1 vapmod=2 grflag=1 gdis_t=185n \
        gdis_b=185n gdis_l=102n gdis_r=102n
CF2 (net11 OUTN VSS) cfmom_wo_p80 dmflag=0 lr=1u multi=1 mxd_flag=0 nr=192 \
        n_mxa=2 shield=2 spm=3 stm=1 vapmod=2 grflag=1 gdis_t=185n \
        gdis_b=185n gdis_l=102n gdis_r=102n
CF1 (net12 OUTN VSS) cfmom_wo_p80 dmflag=0 lr=1u multi=1 mxd_flag=0 nr=192 \
        n_mxa=2 shield=2 spm=3 stm=1 vapmod=2 grflag=1 gdis_t=185n \
        gdis_b=185n gdis_l=102n gdis_r=102n
CF0 (OUTP OUTN VSS) cfmom_wo_p80 dmflag=0 lr=1u multi=1 mxd_flag=0 nr=192 \
        n_mxa=2 shield=2 spm=3 stm=1 vapmod=2 grflag=1 gdis_t=185n \
        gdis_b=185n gdis_l=102n gdis_r=102n
CV1 (OUTN VCTRL VCTRL) moscap_rf wr=538n nfin=12 lr=200n gr=2 br=2 multi=1 \
        sobn=470n sobs=470n sobw=684n sobe=684n
CV0 (OUTP VCTRL VCTRL) moscap_rf wr=538n nfin=12 lr=200n gr=2 br=2 multi=1 \
        sobn=470n sobs=470n sobw=684n sobe=684n
ends vco_x

subckt dtc_x (CK_IN CK_OUT VDD VSS CODE0 CODE1 CODE2 CODE3 CODE4 CODE5 CODE6 CODE7 CODE8 CODE9 CODE10 CODE11 CODE12 CODE13 CODE14 CODE15 CODE16 CODE17 CODE18 CODE19 CODE20 CODE21 CODE22 CODE23 CODE24 CODE25 CODE26 CODE27 CODE28 CODE29 CODE30 CODE31 CODE32 CODE33 CODE34 CODE35 CODE36 CODE37 CODE38 CODE39 CODE40 CODE41 CODE42 CODE43 CODE44 CODE45 CODE46 CODE47 CODE48 CODE49 CODE50 CODE51 CODE52 CODE53 CODE54 CODE55 CODE56 CODE57 CODE58 CODE59 CODE60 CODE61 CODE62 CODE63 CODE64 CODE65 CODE66 CODE67 CODE68 CODE69 CODE70 CODE71 CODE72 CODE73 CODE74 CODE75 CODE76 CODE77 CODE78 CODE79 CODE80 CODE81 CODE82 CODE83 CODE84 CODE85 CODE86 CODE87 CODE88 CODE89 CODE90 CODE91 CODE92 CODE93 CODE94 CODE95 CODE96 CODE97 CODE98 CODE99 CODE100 CODE101 CODE102 CODE103 CODE104 CODE105 CODE106 CODE107 CODE108 CODE109 CODE110 CODE111 CODE112 CODE113 CODE114 CODE115 CODE116 CODE117 CODE118 CODE119 CODE120 CODE121 CODE122 CODE123 CODE124 CODE125 CODE126 CODE127 CODE128 CODE129 CODE130 CODE131 CODE132 CODE133 CODE134 CODE135 CODE136 CODE137 CODE138 CODE139 CODE140 CODE141 CODE142 CODE143 CODE144 CODE145 CODE146 CODE147 CODE148 CODE149 CODE150 CODE151 CODE152 CODE153 CODE154 CODE155 CODE156 CODE157 CODE158 CODE159 CODE160 CODE161 CODE162 CODE163 CODE164 CODE165 CODE166 CODE167 CODE168 CODE169 CODE170 CODE171 CODE172 CODE173 CODE174 CODE175 CODE176 CODE177 CODE178 CODE179 CODE180 CODE181 CODE182 CODE183 CODE184 CODE185 CODE186 CODE187 CODE188 CODE189 CODE190 CODE191 CODE192 CODE193 CODE194 CODE195 CODE196 CODE197 CODE198 CODE199 CODE200 CODE201 CODE202 CODE203 CODE204 CODE205 CODE206 CODE207 CODE208 CODE209 CODE210 CODE211 CODE212 CODE213 CODE214 CODE215 CODE216 CODE217 CODE218 CODE219 CODE220 CODE221 CODE222 CODE223 CODE224 CODE225 CODE226 CODE227 CODE228 CODE229 CODE230 CODE231 CODE232 CODE233 CODE234 CODE235 CODE236 CODE237 CODE238 CODE239 CODE240 CODE241 CODE242 CODE243 CODE244 CODE245 CODE246 CODE247 CODE248 CODE249 CODE250 CODE251 CODE252 CODE253 CODE254 CODE255 CODE256 CODE257 CODE258 CODE259 CODE260 CODE261 CODE262 CODE263 CODE264 CODE265 CODE266 CODE267 CODE268 CODE269 CODE270 CODE271 CODE272 CODE273 CODE274 CODE275 CODE276 CODE277 CODE278 CODE279 CODE280 CODE281 CODE282 CODE283 CODE284 CODE285 CODE286 CODE287 CODE288 CODE289 CODE290 CODE291 CODE292 CODE293 CODE294 CODE295 CODE296 CODE297 CODE298 CODE299 CODE300 CODE301 CODE302 CODE303 CODE304 CODE305 CODE306 CODE307 CODE308 CODE309 CODE310 CODE311 CODE312 CODE313 CODE314 CODE315 CODE316 CODE317 CODE318 CODE319 CODE320 CODE321 CODE322 CODE323 CODE324 CODE325 CODE326 CODE327 CODE328 CODE329 CODE330 CODE331 CODE332 CODE333 CODE334 CODE335 CODE336 CODE337 CODE338 CODE339 CODE340 CODE341 CODE342 CODE343 CODE344 CODE345 CODE346 CODE347 CODE348 CODE349 CODE350 CODE351 CODE352 CODE353 CODE354 CODE355 CODE356 CODE357 CODE358 CODE359 CODE360 CODE361 CODE362 CODE363 CODE364 CODE365 CODE366 CODE367 CODE368 CODE369 CODE370 CODE371 CODE372 CODE373 CODE374 CODE375 CODE376 CODE377 CODE378 CODE379 CODE380 CODE381 CODE382 CODE383 CODE384 CODE385 CODE386 CODE387 CODE388 CODE389 CODE390 CODE391 CODE392 CODE393 CODE394 CODE395 CODE396 CODE397 CODE398 CODE399 CODE400 CODE401 CODE402 CODE403 CODE404 CODE405 CODE406 CODE407 CODE408 CODE409 CODE410 CODE411 CODE412 CODE413 CODE414 CODE415 CODE416 CODE417 CODE418 CODE419 CODE420 CODE421 CODE422 CODE423 CODE424 CODE425 CODE426 CODE427 CODE428 CODE429 CODE430 CODE431 CODE432 CODE433 CODE434 CODE435 CODE436 CODE437 CODE438 CODE439 CODE440 CODE441 CODE442 CODE443 CODE444 CODE445 CODE446 CODE447 CODE448 CODE449 CODE450 CODE451 CODE452 CODE453 CODE454 CODE455 CODE456 CODE457 CODE458 CODE459 CODE460 CODE461 CODE462 CODE463 CODE464 CODE465 CODE466 CODE467 CODE468 CODE469 CODE470 CODE471 CODE472 CODE473 CODE474 CODE475 CODE476 CODE477 CODE478 CODE479 CODE480 CODE481 CODE482 CODE483 CODE484 CODE485 CODE486 CODE487 CODE488 CODE489 CODE490 CODE491 CODE492 CODE493 CODE494 CODE495 CODE496 CODE497 CODE498 CODE499 CODE500 CODE501 CODE502 CODE503 CODE504 CODE505 CODE506 CODE507 CODE508 CODE509 CODE510)

R0 (CK_IN VDLY ) rhim l=2u w=1u multi=(1)

U510 (VDLY CODE510 VDLY VSS) nch_svt_mac l=16n nfin=2 w=58n multi=1 nf=8 \
        sd=74n sa=90n sb=90n ploda1=16n ploda2=0 ploda3=0 plodb1=16n \
        plodb2=0 plodb3=0 nf_flag=1 smbt=1M smbb=1M dinsaflag=0 ppitch=0 \
        spot=103n spob=103n spotl1=103n spobl1=103n spotl2=103n \
        spobl2=103n spotr1=103n spobr1=103n spotr2=103n spobr2=103n
U509 (VDLY CODE509 VDLY VSS) nch_svt_mac l=16n nfin=2 w=58n multi=1 nf=8 \
        sd=74n sa=90n sb=90n ploda1=16n ploda2=0 ploda3=0 plodb1=16n \
        plodb2=0 plodb3=0 nf_flag=1 smbt=1M smbb=1M dinsaflag=0 ppitch=0 \
        spot=103n spob=103n spotl1=103n spobl1=103n spotl2=103n \
        spobl2=103n spotr1=103n spobr1=103n spotr2=103n spobr2=103n
U508 (VDLY CODE508 VDLY VSS) nch_svt_mac l=16n nfin=2 w=58n multi=1 nf=8 \
        sd=74n sa=90n sb=90n ploda1=16n ploda2=0 ploda3=0 plodb1=16n \
        plodb2=0 plodb3=0 nf_flag=1 smbt=1M smbb=1M dinsaflag=0 ppitch=0 \
        spot=103n spob=103n spotl1=103n spobl1=103n spotl2=103n \
        spobl2=103n spotr1=103n spobr1=103n spotr2=103n spobr2=103n
U507 (VDLY CODE507 VDLY VSS) nch_svt_mac l=16n nfin=2 w=58n multi=1 nf=8 \
        sd=74n sa=90n sb=90n ploda1=16n ploda2=0 ploda3=0 plodb1=16n \
        plodb2=0 plodb3=0 nf_flag=1 smbt=1M smbb=1M dinsaflag=0 ppitch=0 \
        spot=103n spob=103n spotl1=103n spobl1=103n spotl2=103n \
        spobl2=103n spotr1=103n spobr1=103n spotr2=103n spobr2=103n
U506 (VDLY CODE506 VDLY VSS) nch_svt_mac l=16n nfin=2 w=58n multi=1 nf=8 \
        sd=74n sa=90n sb=90n ploda1=16n ploda2=0 ploda3=0 plodb1=16n \
        plodb2=0 plodb3=0 nf_flag=1 smbt=1M smbb=1M dinsaflag=0 ppitch=0 \
        spot=103n spob=103n spotl1=103n spobl1=103n spotl2=103n \
        spobl2=103n spotr1=103n spobr1=103n spotr2=103n spobr2=103n
U505 (VDLY CODE505 VDLY VSS) nch_svt_mac l=16n nfin=2 w=58n multi=1 nf=8 \
        sd=74n sa=90n sb=90n ploda1=16n ploda2=0 ploda3=0 plodb1=16n \
        plodb2=0 plodb3=0 nf_flag=1 smbt=1M smbb=1M dinsaflag=0 ppitch=0 \
        spot=103n spob=103n spotl1=103n spobl1=103n spotl2=103n \
        spobl2=103n spotr1=103n spobr1=103n spotr2=103n spobr2=103n
U504 (VDLY CODE504 VDLY VSS) nch_svt_mac l=16n nfin=2 w=58n multi=1 nf=8 \
        sd=74n sa=90n sb=90n ploda1=16n ploda2=0 ploda3=0 plodb1=16n \
        plodb2=0 plodb3=0 nf_flag=1 smbt=1M smbb=1M dinsaflag=0 ppitch=0 \
        spot=103n spob=103n spotl1=103n spobl1=103n spotl2=103n \
        spobl2=103n spotr1=103n spobr1=103n spotr2=103n spobr2=103n
U503 (VDLY CODE503 VDLY VSS) nch_svt_mac l=16n nfin=2 w=58n multi=1 nf=8 \
        sd=74n sa=90n sb=90n ploda1=16n ploda2=0 ploda3=0 plodb1=16n \
        plodb2=0 plodb3=0 nf_flag=1 smbt=1M smbb=1M dinsaflag=0 ppitch=0 \
        spot=103n spob=103n spotl1=103n spobl1=103n spotl2=103n \
        spobl2=103n spotr1=103n spobr1=103n spotr2=103n spobr2=103n
U502 (VDLY CODE502 VDLY VSS) nch_svt_mac l=16n nfin=2 w=58n multi=1 nf=8 \
        sd=74n sa=90n sb=90n ploda1=16n ploda2=0 ploda3=0 plodb1=16n \
        plodb2=0 plodb3=0 nf_flag=1 smbt=1M smbb=1M dinsaflag=0 ppitch=0 \
        spot=103n spob=103n spotl1=103n spobl1=103n spotl2=103n \
        spobl2=103n spotr1=103n spobr1=103n spotr2=103n spobr2=103n
U501 (VDLY CODE501 VDLY VSS) nch_svt_mac l=16n nfin=2 w=58n multi=1 nf=8 \
        sd=74n sa=90n sb=90n ploda1=16n ploda2=0 ploda3=0 plodb1=16n \
        plodb2=0 plodb3=0 nf_flag=1 smbt=1M smbb=1M dinsaflag=0 ppitch=0 \
        spot=103n spob=103n spotl1=103n spobl1=103n spotl2=103n \
        spobl2=103n spotr1=103n spobr1=103n spotr2=103n spobr2=103n
U500 (VDLY CODE500 VDLY VSS) nch_svt_mac l=16n nfin=2 w=58n multi=1 nf=8 \
        sd=74n sa=90n sb=90n ploda1=16n ploda2=0 ploda3=0 plodb1=16n \
        plodb2=0 plodb3=0 nf_flag=1 smbt=1M smbb=1M dinsaflag=0 ppitch=0 \
        spot=103n spob=103n spotl1=103n spobl1=103n spotl2=103n \
        spobl2=103n spotr1=103n spobr1=103n spotr2=103n spobr2=103n
U499 (VDLY CODE499 VDLY VSS) nch_svt_mac l=16n nfin=2 w=58n multi=1 nf=8 \
        sd=74n sa=90n sb=90n ploda1=16n ploda2=0 ploda3=0 plodb1=16n \
        plodb2=0 plodb3=0 nf_flag=1 smbt=1M smbb=1M dinsaflag=0 ppitch=0 \
        spot=103n spob=103n spotl1=103n spobl1=103n spotl2=103n \
        spobl2=103n spotr1=103n spobr1=103n spotr2=103n spobr2=103n
U498 (VDLY CODE498 VDLY VSS) nch_svt_mac l=16n nfin=2 w=58n multi=1 nf=8 \
        sd=74n sa=90n sb=90n ploda1=16n ploda2=0 ploda3=0 plodb1=16n \
        plodb2=0 plodb3=0 nf_flag=1 smbt=1M smbb=1M dinsaflag=0 ppitch=0 \
        spot=103n spob=103n spotl1=103n spobl1=103n spotl2=103n \
        spobl2=103n spotr1=103n spobr1=103n spotr2=103n spobr2=103n
U497 (VDLY CODE497 VDLY VSS) nch_svt_mac l=16n nfin=2 w=58n multi=1 nf=8 \
        sd=74n sa=90n sb=90n ploda1=16n ploda2=0 ploda3=0 plodb1=16n \
        plodb2=0 plodb3=0 nf_flag=1 smbt=1M smbb=1M dinsaflag=0 ppitch=0 \
        spot=103n spob=103n spotl1=103n spobl1=103n spotl2=103n \
        spobl2=103n spotr1=103n spobr1=103n spotr2=103n spobr2=103n
U496 (VDLY CODE496 VDLY VSS) nch_svt_mac l=16n nfin=2 w=58n multi=1 nf=8 \
        sd=74n sa=90n sb=90n ploda1=16n ploda2=0 ploda3=0 plodb1=16n \
        plodb2=0 plodb3=0 nf_flag=1 smbt=1M smbb=1M dinsaflag=0 ppitch=0 \
        spot=103n spob=103n spotl1=103n spobl1=103n spotl2=103n \
        spobl2=103n spotr1=103n spobr1=103n spotr2=103n spobr2=103n
U495 (VDLY CODE495 VDLY VSS) nch_svt_mac l=16n nfin=2 w=58n multi=1 nf=8 \
        sd=74n sa=90n sb=90n ploda1=16n ploda2=0 ploda3=0 plodb1=16n \
        plodb2=0 plodb3=0 nf_flag=1 smbt=1M smbb=1M dinsaflag=0 ppitch=0 \
        spot=103n spob=103n spotl1=103n spobl1=103n spotl2=103n \
        spobl2=103n spotr1=103n spobr1=103n spotr2=103n spobr2=103n
U494 (VDLY CODE494 VDLY VSS) nch_svt_mac l=16n nfin=2 w=58n multi=1 nf=8 \
        sd=74n sa=90n sb=90n ploda1=16n ploda2=0 ploda3=0 plodb1=16n \
        plodb2=0 plodb3=0 nf_flag=1 smbt=1M smbb=1M dinsaflag=0 ppitch=0 \
        spot=103n spob=103n spotl1=103n spobl1=103n spotl2=103n \
        spobl2=103n spotr1=103n spobr1=103n spotr2=103n spobr2=103n
U493 (VDLY CODE493 VDLY VSS) nch_svt_mac l=16n nfin=2 w=58n multi=1 nf=8 \
        sd=74n sa=90n sb=90n ploda1=16n ploda2=0 ploda3=0 plodb1=16n \
        plodb2=0 plodb3=0 nf_flag=1 smbt=1M smbb=1M dinsaflag=0 ppitch=0 \
        spot=103n spob=103n spotl1=103n spobl1=103n spotl2=103n \
        spobl2=103n spotr1=103n spobr1=103n spotr2=103n spobr2=103n
U492 (VDLY CODE492 VDLY VSS) nch_svt_mac l=16n nfin=2 w=58n multi=1 nf=8 \
        sd=74n sa=90n sb=90n ploda1=16n ploda2=0 ploda3=0 plodb1=16n \
        plodb2=0 plodb3=0 nf_flag=1 smbt=1M smbb=1M dinsaflag=0 ppitch=0 \
        spot=103n spob=103n spotl1=103n spobl1=103n spotl2=103n \
        spobl2=103n spotr1=103n spobr1=103n spotr2=103n spobr2=103n
U491 (VDLY CODE491 VDLY VSS) nch_svt_mac l=16n nfin=2 w=58n multi=1 nf=8 \
        sd=74n sa=90n sb=90n ploda1=16n ploda2=0 ploda3=0 plodb1=16n \
        plodb2=0 plodb3=0 nf_flag=1 smbt=1M smbb=1M dinsaflag=0 ppitch=0 \
        spot=103n spob=103n spotl1=103n spobl1=103n spotl2=103n \
        spobl2=103n spotr1=103n spobr1=103n spotr2=103n spobr2=103n
U490 (VDLY CODE490 VDLY VSS) nch_svt_mac l=16n nfin=2 w=58n multi=1 nf=8 \
        sd=74n sa=90n sb=90n ploda1=16n ploda2=0 ploda3=0 plodb1=16n \
        plodb2=0 plodb3=0 nf_flag=1 smbt=1M smbb=1M dinsaflag=0 ppitch=0 \
        spot=103n spob=103n spotl1=103n spobl1=103n spotl2=103n \
        spobl2=103n spotr1=103n spobr1=103n spotr2=103n spobr2=103n
U489 (VDLY CODE489 VDLY VSS) nch_svt_mac l=16n nfin=2 w=58n multi=1 nf=8 \
        sd=74n sa=90n sb=90n ploda1=16n ploda2=0 ploda3=0 plodb1=16n \
        plodb2=0 plodb3=0 nf_flag=1 smbt=1M smbb=1M dinsaflag=0 ppitch=0 \
        spot=103n spob=103n spotl1=103n spobl1=103n spotl2=103n \
        spobl2=103n spotr1=103n spobr1=103n spotr2=103n spobr2=103n
U488 (VDLY CODE488 VDLY VSS) nch_svt_mac l=16n nfin=2 w=58n multi=1 nf=8 \
        sd=74n sa=90n sb=90n ploda1=16n ploda2=0 ploda3=0 plodb1=16n \
        plodb2=0 plodb3=0 nf_flag=1 smbt=1M smbb=1M dinsaflag=0 ppitch=0 \
        spot=103n spob=103n spotl1=103n spobl1=103n spotl2=103n \
        spobl2=103n spotr1=103n spobr1=103n spotr2=103n spobr2=103n
U487 (VDLY CODE487 VDLY VSS) nch_svt_mac l=16n nfin=2 w=58n multi=1 nf=8 \
        sd=74n sa=90n sb=90n ploda1=16n ploda2=0 ploda3=0 plodb1=16n \
        plodb2=0 plodb3=0 nf_flag=1 smbt=1M smbb=1M dinsaflag=0 ppitch=0 \
        spot=103n spob=103n spotl1=103n spobl1=103n spotl2=103n \
        spobl2=103n spotr1=103n spobr1=103n spotr2=103n spobr2=103n
U486 (VDLY CODE486 VDLY VSS) nch_svt_mac l=16n nfin=2 w=58n multi=1 nf=8 \
        sd=74n sa=90n sb=90n ploda1=16n ploda2=0 ploda3=0 plodb1=16n \
        plodb2=0 plodb3=0 nf_flag=1 smbt=1M smbb=1M dinsaflag=0 ppitch=0 \
        spot=103n spob=103n spotl1=103n spobl1=103n spotl2=103n \
        spobl2=103n spotr1=103n spobr1=103n spotr2=103n spobr2=103n
U485 (VDLY CODE485 VDLY VSS) nch_svt_mac l=16n nfin=2 w=58n multi=1 nf=8 \
        sd=74n sa=90n sb=90n ploda1=16n ploda2=0 ploda3=0 plodb1=16n \
        plodb2=0 plodb3=0 nf_flag=1 smbt=1M smbb=1M dinsaflag=0 ppitch=0 \
        spot=103n spob=103n spotl1=103n spobl1=103n spotl2=103n \
        spobl2=103n spotr1=103n spobr1=103n spotr2=103n spobr2=103n
U484 (VDLY CODE484 VDLY VSS) nch_svt_mac l=16n nfin=2 w=58n multi=1 nf=8 \
        sd=74n sa=90n sb=90n ploda1=16n ploda2=0 ploda3=0 plodb1=16n \
        plodb2=0 plodb3=0 nf_flag=1 smbt=1M smbb=1M dinsaflag=0 ppitch=0 \
        spot=103n spob=103n spotl1=103n spobl1=103n spotl2=103n \
        spobl2=103n spotr1=103n spobr1=103n spotr2=103n spobr2=103n
U483 (VDLY CODE483 VDLY VSS) nch_svt_mac l=16n nfin=2 w=58n multi=1 nf=8 \
        sd=74n sa=90n sb=90n ploda1=16n ploda2=0 ploda3=0 plodb1=16n \
        plodb2=0 plodb3=0 nf_flag=1 smbt=1M smbb=1M dinsaflag=0 ppitch=0 \
        spot=103n spob=103n spotl1=103n spobl1=103n spotl2=103n \
        spobl2=103n spotr1=103n spobr1=103n spotr2=103n spobr2=103n
U482 (VDLY CODE482 VDLY VSS) nch_svt_mac l=16n nfin=2 w=58n multi=1 nf=8 \
        sd=74n sa=90n sb=90n ploda1=16n ploda2=0 ploda3=0 plodb1=16n \
        plodb2=0 plodb3=0 nf_flag=1 smbt=1M smbb=1M dinsaflag=0 ppitch=0 \
        spot=103n spob=103n spotl1=103n spobl1=103n spotl2=103n \
        spobl2=103n spotr1=103n spobr1=103n spotr2=103n spobr2=103n
U481 (VDLY CODE481 VDLY VSS) nch_svt_mac l=16n nfin=2 w=58n multi=1 nf=8 \
        sd=74n sa=90n sb=90n ploda1=16n ploda2=0 ploda3=0 plodb1=16n \
        plodb2=0 plodb3=0 nf_flag=1 smbt=1M smbb=1M dinsaflag=0 ppitch=0 \
        spot=103n spob=103n spotl1=103n spobl1=103n spotl2=103n \
        spobl2=103n spotr1=103n spobr1=103n spotr2=103n spobr2=103n
U480 (VDLY CODE480 VDLY VSS) nch_svt_mac l=16n nfin=2 w=58n multi=1 nf=8 \
        sd=74n sa=90n sb=90n ploda1=16n ploda2=0 ploda3=0 plodb1=16n \
        plodb2=0 plodb3=0 nf_flag=1 smbt=1M smbb=1M dinsaflag=0 ppitch=0 \
        spot=103n spob=103n spotl1=103n spobl1=103n spotl2=103n \
        spobl2=103n spotr1=103n spobr1=103n spotr2=103n spobr2=103n
U479 (VDLY CODE479 VDLY VSS) nch_svt_mac l=16n nfin=2 w=58n multi=1 nf=8 \
        sd=74n sa=90n sb=90n ploda1=16n ploda2=0 ploda3=0 plodb1=16n \
        plodb2=0 plodb3=0 nf_flag=1 smbt=1M smbb=1M dinsaflag=0 ppitch=0 \
        spot=103n spob=103n spotl1=103n spobl1=103n spotl2=103n \
        spobl2=103n spotr1=103n spobr1=103n spotr2=103n spobr2=103n
U478 (VDLY CODE478 VDLY VSS) nch_svt_mac l=16n nfin=2 w=58n multi=1 nf=8 \
        sd=74n sa=90n sb=90n ploda1=16n ploda2=0 ploda3=0 plodb1=16n \
        plodb2=0 plodb3=0 nf_flag=1 smbt=1M smbb=1M dinsaflag=0 ppitch=0 \
        spot=103n spob=103n spotl1=103n spobl1=103n spotl2=103n \
        spobl2=103n spotr1=103n spobr1=103n spotr2=103n spobr2=103n
U477 (VDLY CODE477 VDLY VSS) nch_svt_mac l=16n nfin=2 w=58n multi=1 nf=8 \
        sd=74n sa=90n sb=90n ploda1=16n ploda2=0 ploda3=0 plodb1=16n \
        plodb2=0 plodb3=0 nf_flag=1 smbt=1M smbb=1M dinsaflag=0 ppitch=0 \
        spot=103n spob=103n spotl1=103n spobl1=103n spotl2=103n \
        spobl2=103n spotr1=103n spobr1=103n spotr2=103n spobr2=103n
U476 (VDLY CODE476 VDLY VSS) nch_svt_mac l=16n nfin=2 w=58n multi=1 nf=8 \
        sd=74n sa=90n sb=90n ploda1=16n ploda2=0 ploda3=0 plodb1=16n \
        plodb2=0 plodb3=0 nf_flag=1 smbt=1M smbb=1M dinsaflag=0 ppitch=0 \
        spot=103n spob=103n spotl1=103n spobl1=103n spotl2=103n \
        spobl2=103n spotr1=103n spobr1=103n spotr2=103n spobr2=103n
U475 (VDLY CODE475 VDLY VSS) nch_svt_mac l=16n nfin=2 w=58n multi=1 nf=8 \
        sd=74n sa=90n sb=90n ploda1=16n ploda2=0 ploda3=0 plodb1=16n \
        plodb2=0 plodb3=0 nf_flag=1 smbt=1M smbb=1M dinsaflag=0 ppitch=0 \
        spot=103n spob=103n spotl1=103n spobl1=103n spotl2=103n \
        spobl2=103n spotr1=103n spobr1=103n spotr2=103n spobr2=103n
U474 (VDLY CODE474 VDLY VSS) nch_svt_mac l=16n nfin=2 w=58n multi=1 nf=8 \
        sd=74n sa=90n sb=90n ploda1=16n ploda2=0 ploda3=0 plodb1=16n \
        plodb2=0 plodb3=0 nf_flag=1 smbt=1M smbb=1M dinsaflag=0 ppitch=0 \
        spot=103n spob=103n spotl1=103n spobl1=103n spotl2=103n \
        spobl2=103n spotr1=103n spobr1=103n spotr2=103n spobr2=103n
U473 (VDLY CODE473 VDLY VSS) nch_svt_mac l=16n nfin=2 w=58n multi=1 nf=8 \
        sd=74n sa=90n sb=90n ploda1=16n ploda2=0 ploda3=0 plodb1=16n \
        plodb2=0 plodb3=0 nf_flag=1 smbt=1M smbb=1M dinsaflag=0 ppitch=0 \
        spot=103n spob=103n spotl1=103n spobl1=103n spotl2=103n \
        spobl2=103n spotr1=103n spobr1=103n spotr2=103n spobr2=103n
U472 (VDLY CODE472 VDLY VSS) nch_svt_mac l=16n nfin=2 w=58n multi=1 nf=8 \
        sd=74n sa=90n sb=90n ploda1=16n ploda2=0 ploda3=0 plodb1=16n \
        plodb2=0 plodb3=0 nf_flag=1 smbt=1M smbb=1M dinsaflag=0 ppitch=0 \
        spot=103n spob=103n spotl1=103n spobl1=103n spotl2=103n \
        spobl2=103n spotr1=103n spobr1=103n spotr2=103n spobr2=103n
U471 (VDLY CODE471 VDLY VSS) nch_svt_mac l=16n nfin=2 w=58n multi=1 nf=8 \
        sd=74n sa=90n sb=90n ploda1=16n ploda2=0 ploda3=0 plodb1=16n \
        plodb2=0 plodb3=0 nf_flag=1 smbt=1M smbb=1M dinsaflag=0 ppitch=0 \
        spot=103n spob=103n spotl1=103n spobl1=103n spotl2=103n \
        spobl2=103n spotr1=103n spobr1=103n spotr2=103n spobr2=103n
U470 (VDLY CODE470 VDLY VSS) nch_svt_mac l=16n nfin=2 w=58n multi=1 nf=8 \
        sd=74n sa=90n sb=90n ploda1=16n ploda2=0 ploda3=0 plodb1=16n \
        plodb2=0 plodb3=0 nf_flag=1 smbt=1M smbb=1M dinsaflag=0 ppitch=0 \
        spot=103n spob=103n spotl1=103n spobl1=103n spotl2=103n \
        spobl2=103n spotr1=103n spobr1=103n spotr2=103n spobr2=103n
U469 (VDLY CODE469 VDLY VSS) nch_svt_mac l=16n nfin=2 w=58n multi=1 nf=8 \
        sd=74n sa=90n sb=90n ploda1=16n ploda2=0 ploda3=0 plodb1=16n \
        plodb2=0 plodb3=0 nf_flag=1 smbt=1M smbb=1M dinsaflag=0 ppitch=0 \
        spot=103n spob=103n spotl1=103n spobl1=103n spotl2=103n \
        spobl2=103n spotr1=103n spobr1=103n spotr2=103n spobr2=103n
U468 (VDLY CODE468 VDLY VSS) nch_svt_mac l=16n nfin=2 w=58n multi=1 nf=8 \
        sd=74n sa=90n sb=90n ploda1=16n ploda2=0 ploda3=0 plodb1=16n \
        plodb2=0 plodb3=0 nf_flag=1 smbt=1M smbb=1M dinsaflag=0 ppitch=0 \
        spot=103n spob=103n spotl1=103n spobl1=103n spotl2=103n \
        spobl2=103n spotr1=103n spobr1=103n spotr2=103n spobr2=103n
U467 (VDLY CODE467 VDLY VSS) nch_svt_mac l=16n nfin=2 w=58n multi=1 nf=8 \
        sd=74n sa=90n sb=90n ploda1=16n ploda2=0 ploda3=0 plodb1=16n \
        plodb2=0 plodb3=0 nf_flag=1 smbt=1M smbb=1M dinsaflag=0 ppitch=0 \
        spot=103n spob=103n spotl1=103n spobl1=103n spotl2=103n \
        spobl2=103n spotr1=103n spobr1=103n spotr2=103n spobr2=103n
U466 (VDLY CODE466 VDLY VSS) nch_svt_mac l=16n nfin=2 w=58n multi=1 nf=8 \
        sd=74n sa=90n sb=90n ploda1=16n ploda2=0 ploda3=0 plodb1=16n \
        plodb2=0 plodb3=0 nf_flag=1 smbt=1M smbb=1M dinsaflag=0 ppitch=0 \
        spot=103n spob=103n spotl1=103n spobl1=103n spotl2=103n \
        spobl2=103n spotr1=103n spobr1=103n spotr2=103n spobr2=103n
U465 (VDLY CODE465 VDLY VSS) nch_svt_mac l=16n nfin=2 w=58n multi=1 nf=8 \
        sd=74n sa=90n sb=90n ploda1=16n ploda2=0 ploda3=0 plodb1=16n \
        plodb2=0 plodb3=0 nf_flag=1 smbt=1M smbb=1M dinsaflag=0 ppitch=0 \
        spot=103n spob=103n spotl1=103n spobl1=103n spotl2=103n \
        spobl2=103n spotr1=103n spobr1=103n spotr2=103n spobr2=103n
U464 (VDLY CODE464 VDLY VSS) nch_svt_mac l=16n nfin=2 w=58n multi=1 nf=8 \
        sd=74n sa=90n sb=90n ploda1=16n ploda2=0 ploda3=0 plodb1=16n \
        plodb2=0 plodb3=0 nf_flag=1 smbt=1M smbb=1M dinsaflag=0 ppitch=0 \
        spot=103n spob=103n spotl1=103n spobl1=103n spotl2=103n \
        spobl2=103n spotr1=103n spobr1=103n spotr2=103n spobr2=103n
U463 (VDLY CODE463 VDLY VSS) nch_svt_mac l=16n nfin=2 w=58n multi=1 nf=8 \
        sd=74n sa=90n sb=90n ploda1=16n ploda2=0 ploda3=0 plodb1=16n \
        plodb2=0 plodb3=0 nf_flag=1 smbt=1M smbb=1M dinsaflag=0 ppitch=0 \
        spot=103n spob=103n spotl1=103n spobl1=103n spotl2=103n \
        spobl2=103n spotr1=103n spobr1=103n spotr2=103n spobr2=103n
U462 (VDLY CODE462 VDLY VSS) nch_svt_mac l=16n nfin=2 w=58n multi=1 nf=8 \
        sd=74n sa=90n sb=90n ploda1=16n ploda2=0 ploda3=0 plodb1=16n \
        plodb2=0 plodb3=0 nf_flag=1 smbt=1M smbb=1M dinsaflag=0 ppitch=0 \
        spot=103n spob=103n spotl1=103n spobl1=103n spotl2=103n \
        spobl2=103n spotr1=103n spobr1=103n spotr2=103n spobr2=103n
U461 (VDLY CODE461 VDLY VSS) nch_svt_mac l=16n nfin=2 w=58n multi=1 nf=8 \
        sd=74n sa=90n sb=90n ploda1=16n ploda2=0 ploda3=0 plodb1=16n \
        plodb2=0 plodb3=0 nf_flag=1 smbt=1M smbb=1M dinsaflag=0 ppitch=0 \
        spot=103n spob=103n spotl1=103n spobl1=103n spotl2=103n \
        spobl2=103n spotr1=103n spobr1=103n spotr2=103n spobr2=103n
U460 (VDLY CODE460 VDLY VSS) nch_svt_mac l=16n nfin=2 w=58n multi=1 nf=8 \
        sd=74n sa=90n sb=90n ploda1=16n ploda2=0 ploda3=0 plodb1=16n \
        plodb2=0 plodb3=0 nf_flag=1 smbt=1M smbb=1M dinsaflag=0 ppitch=0 \
        spot=103n spob=103n spotl1=103n spobl1=103n spotl2=103n \
        spobl2=103n spotr1=103n spobr1=103n spotr2=103n spobr2=103n
U459 (VDLY CODE459 VDLY VSS) nch_svt_mac l=16n nfin=2 w=58n multi=1 nf=8 \
        sd=74n sa=90n sb=90n ploda1=16n ploda2=0 ploda3=0 plodb1=16n \
        plodb2=0 plodb3=0 nf_flag=1 smbt=1M smbb=1M dinsaflag=0 ppitch=0 \
        spot=103n spob=103n spotl1=103n spobl1=103n spotl2=103n \
        spobl2=103n spotr1=103n spobr1=103n spotr2=103n spobr2=103n
U458 (VDLY CODE458 VDLY VSS) nch_svt_mac l=16n nfin=2 w=58n multi=1 nf=8 \
        sd=74n sa=90n sb=90n ploda1=16n ploda2=0 ploda3=0 plodb1=16n \
        plodb2=0 plodb3=0 nf_flag=1 smbt=1M smbb=1M dinsaflag=0 ppitch=0 \
        spot=103n spob=103n spotl1=103n spobl1=103n spotl2=103n \
        spobl2=103n spotr1=103n spobr1=103n spotr2=103n spobr2=103n
U457 (VDLY CODE457 VDLY VSS) nch_svt_mac l=16n nfin=2 w=58n multi=1 nf=8 \
        sd=74n sa=90n sb=90n ploda1=16n ploda2=0 ploda3=0 plodb1=16n \
        plodb2=0 plodb3=0 nf_flag=1 smbt=1M smbb=1M dinsaflag=0 ppitch=0 \
        spot=103n spob=103n spotl1=103n spobl1=103n spotl2=103n \
        spobl2=103n spotr1=103n spobr1=103n spotr2=103n spobr2=103n
U456 (VDLY CODE456 VDLY VSS) nch_svt_mac l=16n nfin=2 w=58n multi=1 nf=8 \
        sd=74n sa=90n sb=90n ploda1=16n ploda2=0 ploda3=0 plodb1=16n \
        plodb2=0 plodb3=0 nf_flag=1 smbt=1M smbb=1M dinsaflag=0 ppitch=0 \
        spot=103n spob=103n spotl1=103n spobl1=103n spotl2=103n \
        spobl2=103n spotr1=103n spobr1=103n spotr2=103n spobr2=103n
U455 (VDLY CODE455 VDLY VSS) nch_svt_mac l=16n nfin=2 w=58n multi=1 nf=8 \
        sd=74n sa=90n sb=90n ploda1=16n ploda2=0 ploda3=0 plodb1=16n \
        plodb2=0 plodb3=0 nf_flag=1 smbt=1M smbb=1M dinsaflag=0 ppitch=0 \
        spot=103n spob=103n spotl1=103n spobl1=103n spotl2=103n \
        spobl2=103n spotr1=103n spobr1=103n spotr2=103n spobr2=103n
U454 (VDLY CODE454 VDLY VSS) nch_svt_mac l=16n nfin=2 w=58n multi=1 nf=8 \
        sd=74n sa=90n sb=90n ploda1=16n ploda2=0 ploda3=0 plodb1=16n \
        plodb2=0 plodb3=0 nf_flag=1 smbt=1M smbb=1M dinsaflag=0 ppitch=0 \
        spot=103n spob=103n spotl1=103n spobl1=103n spotl2=103n \
        spobl2=103n spotr1=103n spobr1=103n spotr2=103n spobr2=103n
U453 (VDLY CODE453 VDLY VSS) nch_svt_mac l=16n nfin=2 w=58n multi=1 nf=8 \
        sd=74n sa=90n sb=90n ploda1=16n ploda2=0 ploda3=0 plodb1=16n \
        plodb2=0 plodb3=0 nf_flag=1 smbt=1M smbb=1M dinsaflag=0 ppitch=0 \
        spot=103n spob=103n spotl1=103n spobl1=103n spotl2=103n \
        spobl2=103n spotr1=103n spobr1=103n spotr2=103n spobr2=103n
U452 (VDLY CODE452 VDLY VSS) nch_svt_mac l=16n nfin=2 w=58n multi=1 nf=8 \
        sd=74n sa=90n sb=90n ploda1=16n ploda2=0 ploda3=0 plodb1=16n \
        plodb2=0 plodb3=0 nf_flag=1 smbt=1M smbb=1M dinsaflag=0 ppitch=0 \
        spot=103n spob=103n spotl1=103n spobl1=103n spotl2=103n \
        spobl2=103n spotr1=103n spobr1=103n spotr2=103n spobr2=103n
U451 (VDLY CODE451 VDLY VSS) nch_svt_mac l=16n nfin=2 w=58n multi=1 nf=8 \
        sd=74n sa=90n sb=90n ploda1=16n ploda2=0 ploda3=0 plodb1=16n \
        plodb2=0 plodb3=0 nf_flag=1 smbt=1M smbb=1M dinsaflag=0 ppitch=0 \
        spot=103n spob=103n spotl1=103n spobl1=103n spotl2=103n \
        spobl2=103n spotr1=103n spobr1=103n spotr2=103n spobr2=103n
U450 (VDLY CODE450 VDLY VSS) nch_svt_mac l=16n nfin=2 w=58n multi=1 nf=8 \
        sd=74n sa=90n sb=90n ploda1=16n ploda2=0 ploda3=0 plodb1=16n \
        plodb2=0 plodb3=0 nf_flag=1 smbt=1M smbb=1M dinsaflag=0 ppitch=0 \
        spot=103n spob=103n spotl1=103n spobl1=103n spotl2=103n \
        spobl2=103n spotr1=103n spobr1=103n spotr2=103n spobr2=103n
U449 (VDLY CODE449 VDLY VSS) nch_svt_mac l=16n nfin=2 w=58n multi=1 nf=8 \
        sd=74n sa=90n sb=90n ploda1=16n ploda2=0 ploda3=0 plodb1=16n \
        plodb2=0 plodb3=0 nf_flag=1 smbt=1M smbb=1M dinsaflag=0 ppitch=0 \
        spot=103n spob=103n spotl1=103n spobl1=103n spotl2=103n \
        spobl2=103n spotr1=103n spobr1=103n spotr2=103n spobr2=103n
U448 (VDLY CODE448 VDLY VSS) nch_svt_mac l=16n nfin=2 w=58n multi=1 nf=8 \
        sd=74n sa=90n sb=90n ploda1=16n ploda2=0 ploda3=0 plodb1=16n \
        plodb2=0 plodb3=0 nf_flag=1 smbt=1M smbb=1M dinsaflag=0 ppitch=0 \
        spot=103n spob=103n spotl1=103n spobl1=103n spotl2=103n \
        spobl2=103n spotr1=103n spobr1=103n spotr2=103n spobr2=103n
U447 (VDLY CODE447 VDLY VSS) nch_svt_mac l=16n nfin=2 w=58n multi=1 nf=8 \
        sd=74n sa=90n sb=90n ploda1=16n ploda2=0 ploda3=0 plodb1=16n \
        plodb2=0 plodb3=0 nf_flag=1 smbt=1M smbb=1M dinsaflag=0 ppitch=0 \
        spot=103n spob=103n spotl1=103n spobl1=103n spotl2=103n \
        spobl2=103n spotr1=103n spobr1=103n spotr2=103n spobr2=103n
U446 (VDLY CODE446 VDLY VSS) nch_svt_mac l=16n nfin=2 w=58n multi=1 nf=8 \
        sd=74n sa=90n sb=90n ploda1=16n ploda2=0 ploda3=0 plodb1=16n \
        plodb2=0 plodb3=0 nf_flag=1 smbt=1M smbb=1M dinsaflag=0 ppitch=0 \
        spot=103n spob=103n spotl1=103n spobl1=103n spotl2=103n \
        spobl2=103n spotr1=103n spobr1=103n spotr2=103n spobr2=103n
U445 (VDLY CODE445 VDLY VSS) nch_svt_mac l=16n nfin=2 w=58n multi=1 nf=8 \
        sd=74n sa=90n sb=90n ploda1=16n ploda2=0 ploda3=0 plodb1=16n \
        plodb2=0 plodb3=0 nf_flag=1 smbt=1M smbb=1M dinsaflag=0 ppitch=0 \
        spot=103n spob=103n spotl1=103n spobl1=103n spotl2=103n \
        spobl2=103n spotr1=103n spobr1=103n spotr2=103n spobr2=103n
U444 (VDLY CODE444 VDLY VSS) nch_svt_mac l=16n nfin=2 w=58n multi=1 nf=8 \
        sd=74n sa=90n sb=90n ploda1=16n ploda2=0 ploda3=0 plodb1=16n \
        plodb2=0 plodb3=0 nf_flag=1 smbt=1M smbb=1M dinsaflag=0 ppitch=0 \
        spot=103n spob=103n spotl1=103n spobl1=103n spotl2=103n \
        spobl2=103n spotr1=103n spobr1=103n spotr2=103n spobr2=103n
U443 (VDLY CODE443 VDLY VSS) nch_svt_mac l=16n nfin=2 w=58n multi=1 nf=8 \
        sd=74n sa=90n sb=90n ploda1=16n ploda2=0 ploda3=0 plodb1=16n \
        plodb2=0 plodb3=0 nf_flag=1 smbt=1M smbb=1M dinsaflag=0 ppitch=0 \
        spot=103n spob=103n spotl1=103n spobl1=103n spotl2=103n \
        spobl2=103n spotr1=103n spobr1=103n spotr2=103n spobr2=103n
U442 (VDLY CODE442 VDLY VSS) nch_svt_mac l=16n nfin=2 w=58n multi=1 nf=8 \
        sd=74n sa=90n sb=90n ploda1=16n ploda2=0 ploda3=0 plodb1=16n \
        plodb2=0 plodb3=0 nf_flag=1 smbt=1M smbb=1M dinsaflag=0 ppitch=0 \
        spot=103n spob=103n spotl1=103n spobl1=103n spotl2=103n \
        spobl2=103n spotr1=103n spobr1=103n spotr2=103n spobr2=103n
U441 (VDLY CODE441 VDLY VSS) nch_svt_mac l=16n nfin=2 w=58n multi=1 nf=8 \
        sd=74n sa=90n sb=90n ploda1=16n ploda2=0 ploda3=0 plodb1=16n \
        plodb2=0 plodb3=0 nf_flag=1 smbt=1M smbb=1M dinsaflag=0 ppitch=0 \
        spot=103n spob=103n spotl1=103n spobl1=103n spotl2=103n \
        spobl2=103n spotr1=103n spobr1=103n spotr2=103n spobr2=103n
U440 (VDLY CODE440 VDLY VSS) nch_svt_mac l=16n nfin=2 w=58n multi=1 nf=8 \
        sd=74n sa=90n sb=90n ploda1=16n ploda2=0 ploda3=0 plodb1=16n \
        plodb2=0 plodb3=0 nf_flag=1 smbt=1M smbb=1M dinsaflag=0 ppitch=0 \
        spot=103n spob=103n spotl1=103n spobl1=103n spotl2=103n \
        spobl2=103n spotr1=103n spobr1=103n spotr2=103n spobr2=103n
U439 (VDLY CODE439 VDLY VSS) nch_svt_mac l=16n nfin=2 w=58n multi=1 nf=8 \
        sd=74n sa=90n sb=90n ploda1=16n ploda2=0 ploda3=0 plodb1=16n \
        plodb2=0 plodb3=0 nf_flag=1 smbt=1M smbb=1M dinsaflag=0 ppitch=0 \
        spot=103n spob=103n spotl1=103n spobl1=103n spotl2=103n \
        spobl2=103n spotr1=103n spobr1=103n spotr2=103n spobr2=103n
U438 (VDLY CODE438 VDLY VSS) nch_svt_mac l=16n nfin=2 w=58n multi=1 nf=8 \
        sd=74n sa=90n sb=90n ploda1=16n ploda2=0 ploda3=0 plodb1=16n \
        plodb2=0 plodb3=0 nf_flag=1 smbt=1M smbb=1M dinsaflag=0 ppitch=0 \
        spot=103n spob=103n spotl1=103n spobl1=103n spotl2=103n \
        spobl2=103n spotr1=103n spobr1=103n spotr2=103n spobr2=103n
U437 (VDLY CODE437 VDLY VSS) nch_svt_mac l=16n nfin=2 w=58n multi=1 nf=8 \
        sd=74n sa=90n sb=90n ploda1=16n ploda2=0 ploda3=0 plodb1=16n \
        plodb2=0 plodb3=0 nf_flag=1 smbt=1M smbb=1M dinsaflag=0 ppitch=0 \
        spot=103n spob=103n spotl1=103n spobl1=103n spotl2=103n \
        spobl2=103n spotr1=103n spobr1=103n spotr2=103n spobr2=103n
U436 (VDLY CODE436 VDLY VSS) nch_svt_mac l=16n nfin=2 w=58n multi=1 nf=8 \
        sd=74n sa=90n sb=90n ploda1=16n ploda2=0 ploda3=0 plodb1=16n \
        plodb2=0 plodb3=0 nf_flag=1 smbt=1M smbb=1M dinsaflag=0 ppitch=0 \
        spot=103n spob=103n spotl1=103n spobl1=103n spotl2=103n \
        spobl2=103n spotr1=103n spobr1=103n spotr2=103n spobr2=103n
U435 (VDLY CODE435 VDLY VSS) nch_svt_mac l=16n nfin=2 w=58n multi=1 nf=8 \
        sd=74n sa=90n sb=90n ploda1=16n ploda2=0 ploda3=0 plodb1=16n \
        plodb2=0 plodb3=0 nf_flag=1 smbt=1M smbb=1M dinsaflag=0 ppitch=0 \
        spot=103n spob=103n spotl1=103n spobl1=103n spotl2=103n \
        spobl2=103n spotr1=103n spobr1=103n spotr2=103n spobr2=103n
U434 (VDLY CODE434 VDLY VSS) nch_svt_mac l=16n nfin=2 w=58n multi=1 nf=8 \
        sd=74n sa=90n sb=90n ploda1=16n ploda2=0 ploda3=0 plodb1=16n \
        plodb2=0 plodb3=0 nf_flag=1 smbt=1M smbb=1M dinsaflag=0 ppitch=0 \
        spot=103n spob=103n spotl1=103n spobl1=103n spotl2=103n \
        spobl2=103n spotr1=103n spobr1=103n spotr2=103n spobr2=103n
U433 (VDLY CODE433 VDLY VSS) nch_svt_mac l=16n nfin=2 w=58n multi=1 nf=8 \
        sd=74n sa=90n sb=90n ploda1=16n ploda2=0 ploda3=0 plodb1=16n \
        plodb2=0 plodb3=0 nf_flag=1 smbt=1M smbb=1M dinsaflag=0 ppitch=0 \
        spot=103n spob=103n spotl1=103n spobl1=103n spotl2=103n \
        spobl2=103n spotr1=103n spobr1=103n spotr2=103n spobr2=103n
U432 (VDLY CODE432 VDLY VSS) nch_svt_mac l=16n nfin=2 w=58n multi=1 nf=8 \
        sd=74n sa=90n sb=90n ploda1=16n ploda2=0 ploda3=0 plodb1=16n \
        plodb2=0 plodb3=0 nf_flag=1 smbt=1M smbb=1M dinsaflag=0 ppitch=0 \
        spot=103n spob=103n spotl1=103n spobl1=103n spotl2=103n \
        spobl2=103n spotr1=103n spobr1=103n spotr2=103n spobr2=103n
U431 (VDLY CODE431 VDLY VSS) nch_svt_mac l=16n nfin=2 w=58n multi=1 nf=8 \
        sd=74n sa=90n sb=90n ploda1=16n ploda2=0 ploda3=0 plodb1=16n \
        plodb2=0 plodb3=0 nf_flag=1 smbt=1M smbb=1M dinsaflag=0 ppitch=0 \
        spot=103n spob=103n spotl1=103n spobl1=103n spotl2=103n \
        spobl2=103n spotr1=103n spobr1=103n spotr2=103n spobr2=103n
U430 (VDLY CODE430 VDLY VSS) nch_svt_mac l=16n nfin=2 w=58n multi=1 nf=8 \
        sd=74n sa=90n sb=90n ploda1=16n ploda2=0 ploda3=0 plodb1=16n \
        plodb2=0 plodb3=0 nf_flag=1 smbt=1M smbb=1M dinsaflag=0 ppitch=0 \
        spot=103n spob=103n spotl1=103n spobl1=103n spotl2=103n \
        spobl2=103n spotr1=103n spobr1=103n spotr2=103n spobr2=103n
U429 (VDLY CODE429 VDLY VSS) nch_svt_mac l=16n nfin=2 w=58n multi=1 nf=8 \
        sd=74n sa=90n sb=90n ploda1=16n ploda2=0 ploda3=0 plodb1=16n \
        plodb2=0 plodb3=0 nf_flag=1 smbt=1M smbb=1M dinsaflag=0 ppitch=0 \
        spot=103n spob=103n spotl1=103n spobl1=103n spotl2=103n \
        spobl2=103n spotr1=103n spobr1=103n spotr2=103n spobr2=103n
U428 (VDLY CODE428 VDLY VSS) nch_svt_mac l=16n nfin=2 w=58n multi=1 nf=8 \
        sd=74n sa=90n sb=90n ploda1=16n ploda2=0 ploda3=0 plodb1=16n \
        plodb2=0 plodb3=0 nf_flag=1 smbt=1M smbb=1M dinsaflag=0 ppitch=0 \
        spot=103n spob=103n spotl1=103n spobl1=103n spotl2=103n \
        spobl2=103n spotr1=103n spobr1=103n spotr2=103n spobr2=103n
U427 (VDLY CODE427 VDLY VSS) nch_svt_mac l=16n nfin=2 w=58n multi=1 nf=8 \
        sd=74n sa=90n sb=90n ploda1=16n ploda2=0 ploda3=0 plodb1=16n \
        plodb2=0 plodb3=0 nf_flag=1 smbt=1M smbb=1M dinsaflag=0 ppitch=0 \
        spot=103n spob=103n spotl1=103n spobl1=103n spotl2=103n \
        spobl2=103n spotr1=103n spobr1=103n spotr2=103n spobr2=103n
U426 (VDLY CODE426 VDLY VSS) nch_svt_mac l=16n nfin=2 w=58n multi=1 nf=8 \
        sd=74n sa=90n sb=90n ploda1=16n ploda2=0 ploda3=0 plodb1=16n \
        plodb2=0 plodb3=0 nf_flag=1 smbt=1M smbb=1M dinsaflag=0 ppitch=0 \
        spot=103n spob=103n spotl1=103n spobl1=103n spotl2=103n \
        spobl2=103n spotr1=103n spobr1=103n spotr2=103n spobr2=103n
U425 (VDLY CODE425 VDLY VSS) nch_svt_mac l=16n nfin=2 w=58n multi=1 nf=8 \
        sd=74n sa=90n sb=90n ploda1=16n ploda2=0 ploda3=0 plodb1=16n \
        plodb2=0 plodb3=0 nf_flag=1 smbt=1M smbb=1M dinsaflag=0 ppitch=0 \
        spot=103n spob=103n spotl1=103n spobl1=103n spotl2=103n \
        spobl2=103n spotr1=103n spobr1=103n spotr2=103n spobr2=103n
U424 (VDLY CODE424 VDLY VSS) nch_svt_mac l=16n nfin=2 w=58n multi=1 nf=8 \
        sd=74n sa=90n sb=90n ploda1=16n ploda2=0 ploda3=0 plodb1=16n \
        plodb2=0 plodb3=0 nf_flag=1 smbt=1M smbb=1M dinsaflag=0 ppitch=0 \
        spot=103n spob=103n spotl1=103n spobl1=103n spotl2=103n \
        spobl2=103n spotr1=103n spobr1=103n spotr2=103n spobr2=103n
U423 (VDLY CODE423 VDLY VSS) nch_svt_mac l=16n nfin=2 w=58n multi=1 nf=8 \
        sd=74n sa=90n sb=90n ploda1=16n ploda2=0 ploda3=0 plodb1=16n \
        plodb2=0 plodb3=0 nf_flag=1 smbt=1M smbb=1M dinsaflag=0 ppitch=0 \
        spot=103n spob=103n spotl1=103n spobl1=103n spotl2=103n \
        spobl2=103n spotr1=103n spobr1=103n spotr2=103n spobr2=103n
U422 (VDLY CODE422 VDLY VSS) nch_svt_mac l=16n nfin=2 w=58n multi=1 nf=8 \
        sd=74n sa=90n sb=90n ploda1=16n ploda2=0 ploda3=0 plodb1=16n \
        plodb2=0 plodb3=0 nf_flag=1 smbt=1M smbb=1M dinsaflag=0 ppitch=0 \
        spot=103n spob=103n spotl1=103n spobl1=103n spotl2=103n \
        spobl2=103n spotr1=103n spobr1=103n spotr2=103n spobr2=103n
U421 (VDLY CODE421 VDLY VSS) nch_svt_mac l=16n nfin=2 w=58n multi=1 nf=8 \
        sd=74n sa=90n sb=90n ploda1=16n ploda2=0 ploda3=0 plodb1=16n \
        plodb2=0 plodb3=0 nf_flag=1 smbt=1M smbb=1M dinsaflag=0 ppitch=0 \
        spot=103n spob=103n spotl1=103n spobl1=103n spotl2=103n \
        spobl2=103n spotr1=103n spobr1=103n spotr2=103n spobr2=103n
U420 (VDLY CODE420 VDLY VSS) nch_svt_mac l=16n nfin=2 w=58n multi=1 nf=8 \
        sd=74n sa=90n sb=90n ploda1=16n ploda2=0 ploda3=0 plodb1=16n \
        plodb2=0 plodb3=0 nf_flag=1 smbt=1M smbb=1M dinsaflag=0 ppitch=0 \
        spot=103n spob=103n spotl1=103n spobl1=103n spotl2=103n \
        spobl2=103n spotr1=103n spobr1=103n spotr2=103n spobr2=103n
U419 (VDLY CODE419 VDLY VSS) nch_svt_mac l=16n nfin=2 w=58n multi=1 nf=8 \
        sd=74n sa=90n sb=90n ploda1=16n ploda2=0 ploda3=0 plodb1=16n \
        plodb2=0 plodb3=0 nf_flag=1 smbt=1M smbb=1M dinsaflag=0 ppitch=0 \
        spot=103n spob=103n spotl1=103n spobl1=103n spotl2=103n \
        spobl2=103n spotr1=103n spobr1=103n spotr2=103n spobr2=103n
U418 (VDLY CODE418 VDLY VSS) nch_svt_mac l=16n nfin=2 w=58n multi=1 nf=8 \
        sd=74n sa=90n sb=90n ploda1=16n ploda2=0 ploda3=0 plodb1=16n \
        plodb2=0 plodb3=0 nf_flag=1 smbt=1M smbb=1M dinsaflag=0 ppitch=0 \
        spot=103n spob=103n spotl1=103n spobl1=103n spotl2=103n \
        spobl2=103n spotr1=103n spobr1=103n spotr2=103n spobr2=103n
U417 (VDLY CODE417 VDLY VSS) nch_svt_mac l=16n nfin=2 w=58n multi=1 nf=8 \
        sd=74n sa=90n sb=90n ploda1=16n ploda2=0 ploda3=0 plodb1=16n \
        plodb2=0 plodb3=0 nf_flag=1 smbt=1M smbb=1M dinsaflag=0 ppitch=0 \
        spot=103n spob=103n spotl1=103n spobl1=103n spotl2=103n \
        spobl2=103n spotr1=103n spobr1=103n spotr2=103n spobr2=103n
U416 (VDLY CODE416 VDLY VSS) nch_svt_mac l=16n nfin=2 w=58n multi=1 nf=8 \
        sd=74n sa=90n sb=90n ploda1=16n ploda2=0 ploda3=0 plodb1=16n \
        plodb2=0 plodb3=0 nf_flag=1 smbt=1M smbb=1M dinsaflag=0 ppitch=0 \
        spot=103n spob=103n spotl1=103n spobl1=103n spotl2=103n \
        spobl2=103n spotr1=103n spobr1=103n spotr2=103n spobr2=103n
U415 (VDLY CODE415 VDLY VSS) nch_svt_mac l=16n nfin=2 w=58n multi=1 nf=8 \
        sd=74n sa=90n sb=90n ploda1=16n ploda2=0 ploda3=0 plodb1=16n \
        plodb2=0 plodb3=0 nf_flag=1 smbt=1M smbb=1M dinsaflag=0 ppitch=0 \
        spot=103n spob=103n spotl1=103n spobl1=103n spotl2=103n \
        spobl2=103n spotr1=103n spobr1=103n spotr2=103n spobr2=103n
U414 (VDLY CODE414 VDLY VSS) nch_svt_mac l=16n nfin=2 w=58n multi=1 nf=8 \
        sd=74n sa=90n sb=90n ploda1=16n ploda2=0 ploda3=0 plodb1=16n \
        plodb2=0 plodb3=0 nf_flag=1 smbt=1M smbb=1M dinsaflag=0 ppitch=0 \
        spot=103n spob=103n spotl1=103n spobl1=103n spotl2=103n \
        spobl2=103n spotr1=103n spobr1=103n spotr2=103n spobr2=103n
U413 (VDLY CODE413 VDLY VSS) nch_svt_mac l=16n nfin=2 w=58n multi=1 nf=8 \
        sd=74n sa=90n sb=90n ploda1=16n ploda2=0 ploda3=0 plodb1=16n \
        plodb2=0 plodb3=0 nf_flag=1 smbt=1M smbb=1M dinsaflag=0 ppitch=0 \
        spot=103n spob=103n spotl1=103n spobl1=103n spotl2=103n \
        spobl2=103n spotr1=103n spobr1=103n spotr2=103n spobr2=103n
U412 (VDLY CODE412 VDLY VSS) nch_svt_mac l=16n nfin=2 w=58n multi=1 nf=8 \
        sd=74n sa=90n sb=90n ploda1=16n ploda2=0 ploda3=0 plodb1=16n \
        plodb2=0 plodb3=0 nf_flag=1 smbt=1M smbb=1M dinsaflag=0 ppitch=0 \
        spot=103n spob=103n spotl1=103n spobl1=103n spotl2=103n \
        spobl2=103n spotr1=103n spobr1=103n spotr2=103n spobr2=103n
U411 (VDLY CODE411 VDLY VSS) nch_svt_mac l=16n nfin=2 w=58n multi=1 nf=8 \
        sd=74n sa=90n sb=90n ploda1=16n ploda2=0 ploda3=0 plodb1=16n \
        plodb2=0 plodb3=0 nf_flag=1 smbt=1M smbb=1M dinsaflag=0 ppitch=0 \
        spot=103n spob=103n spotl1=103n spobl1=103n spotl2=103n \
        spobl2=103n spotr1=103n spobr1=103n spotr2=103n spobr2=103n
U410 (VDLY CODE410 VDLY VSS) nch_svt_mac l=16n nfin=2 w=58n multi=1 nf=8 \
        sd=74n sa=90n sb=90n ploda1=16n ploda2=0 ploda3=0 plodb1=16n \
        plodb2=0 plodb3=0 nf_flag=1 smbt=1M smbb=1M dinsaflag=0 ppitch=0 \
        spot=103n spob=103n spotl1=103n spobl1=103n spotl2=103n \
        spobl2=103n spotr1=103n spobr1=103n spotr2=103n spobr2=103n
U409 (VDLY CODE409 VDLY VSS) nch_svt_mac l=16n nfin=2 w=58n multi=1 nf=8 \
        sd=74n sa=90n sb=90n ploda1=16n ploda2=0 ploda3=0 plodb1=16n \
        plodb2=0 plodb3=0 nf_flag=1 smbt=1M smbb=1M dinsaflag=0 ppitch=0 \
        spot=103n spob=103n spotl1=103n spobl1=103n spotl2=103n \
        spobl2=103n spotr1=103n spobr1=103n spotr2=103n spobr2=103n
U408 (VDLY CODE408 VDLY VSS) nch_svt_mac l=16n nfin=2 w=58n multi=1 nf=8 \
        sd=74n sa=90n sb=90n ploda1=16n ploda2=0 ploda3=0 plodb1=16n \
        plodb2=0 plodb3=0 nf_flag=1 smbt=1M smbb=1M dinsaflag=0 ppitch=0 \
        spot=103n spob=103n spotl1=103n spobl1=103n spotl2=103n \
        spobl2=103n spotr1=103n spobr1=103n spotr2=103n spobr2=103n
U407 (VDLY CODE407 VDLY VSS) nch_svt_mac l=16n nfin=2 w=58n multi=1 nf=8 \
        sd=74n sa=90n sb=90n ploda1=16n ploda2=0 ploda3=0 plodb1=16n \
        plodb2=0 plodb3=0 nf_flag=1 smbt=1M smbb=1M dinsaflag=0 ppitch=0 \
        spot=103n spob=103n spotl1=103n spobl1=103n spotl2=103n \
        spobl2=103n spotr1=103n spobr1=103n spotr2=103n spobr2=103n
U406 (VDLY CODE406 VDLY VSS) nch_svt_mac l=16n nfin=2 w=58n multi=1 nf=8 \
        sd=74n sa=90n sb=90n ploda1=16n ploda2=0 ploda3=0 plodb1=16n \
        plodb2=0 plodb3=0 nf_flag=1 smbt=1M smbb=1M dinsaflag=0 ppitch=0 \
        spot=103n spob=103n spotl1=103n spobl1=103n spotl2=103n \
        spobl2=103n spotr1=103n spobr1=103n spotr2=103n spobr2=103n
U405 (VDLY CODE405 VDLY VSS) nch_svt_mac l=16n nfin=2 w=58n multi=1 nf=8 \
        sd=74n sa=90n sb=90n ploda1=16n ploda2=0 ploda3=0 plodb1=16n \
        plodb2=0 plodb3=0 nf_flag=1 smbt=1M smbb=1M dinsaflag=0 ppitch=0 \
        spot=103n spob=103n spotl1=103n spobl1=103n spotl2=103n \
        spobl2=103n spotr1=103n spobr1=103n spotr2=103n spobr2=103n
U404 (VDLY CODE404 VDLY VSS) nch_svt_mac l=16n nfin=2 w=58n multi=1 nf=8 \
        sd=74n sa=90n sb=90n ploda1=16n ploda2=0 ploda3=0 plodb1=16n \
        plodb2=0 plodb3=0 nf_flag=1 smbt=1M smbb=1M dinsaflag=0 ppitch=0 \
        spot=103n spob=103n spotl1=103n spobl1=103n spotl2=103n \
        spobl2=103n spotr1=103n spobr1=103n spotr2=103n spobr2=103n
U403 (VDLY CODE403 VDLY VSS) nch_svt_mac l=16n nfin=2 w=58n multi=1 nf=8 \
        sd=74n sa=90n sb=90n ploda1=16n ploda2=0 ploda3=0 plodb1=16n \
        plodb2=0 plodb3=0 nf_flag=1 smbt=1M smbb=1M dinsaflag=0 ppitch=0 \
        spot=103n spob=103n spotl1=103n spobl1=103n spotl2=103n \
        spobl2=103n spotr1=103n spobr1=103n spotr2=103n spobr2=103n
U402 (VDLY CODE402 VDLY VSS) nch_svt_mac l=16n nfin=2 w=58n multi=1 nf=8 \
        sd=74n sa=90n sb=90n ploda1=16n ploda2=0 ploda3=0 plodb1=16n \
        plodb2=0 plodb3=0 nf_flag=1 smbt=1M smbb=1M dinsaflag=0 ppitch=0 \
        spot=103n spob=103n spotl1=103n spobl1=103n spotl2=103n \
        spobl2=103n spotr1=103n spobr1=103n spotr2=103n spobr2=103n
U401 (VDLY CODE401 VDLY VSS) nch_svt_mac l=16n nfin=2 w=58n multi=1 nf=8 \
        sd=74n sa=90n sb=90n ploda1=16n ploda2=0 ploda3=0 plodb1=16n \
        plodb2=0 plodb3=0 nf_flag=1 smbt=1M smbb=1M dinsaflag=0 ppitch=0 \
        spot=103n spob=103n spotl1=103n spobl1=103n spotl2=103n \
        spobl2=103n spotr1=103n spobr1=103n spotr2=103n spobr2=103n
U400 (VDLY CODE400 VDLY VSS) nch_svt_mac l=16n nfin=2 w=58n multi=1 nf=8 \
        sd=74n sa=90n sb=90n ploda1=16n ploda2=0 ploda3=0 plodb1=16n \
        plodb2=0 plodb3=0 nf_flag=1 smbt=1M smbb=1M dinsaflag=0 ppitch=0 \
        spot=103n spob=103n spotl1=103n spobl1=103n spotl2=103n \
        spobl2=103n spotr1=103n spobr1=103n spotr2=103n spobr2=103n
U399 (VDLY CODE399 VDLY VSS) nch_svt_mac l=16n nfin=2 w=58n multi=1 nf=8 \
        sd=74n sa=90n sb=90n ploda1=16n ploda2=0 ploda3=0 plodb1=16n \
        plodb2=0 plodb3=0 nf_flag=1 smbt=1M smbb=1M dinsaflag=0 ppitch=0 \
        spot=103n spob=103n spotl1=103n spobl1=103n spotl2=103n \
        spobl2=103n spotr1=103n spobr1=103n spotr2=103n spobr2=103n
U398 (VDLY CODE398 VDLY VSS) nch_svt_mac l=16n nfin=2 w=58n multi=1 nf=8 \
        sd=74n sa=90n sb=90n ploda1=16n ploda2=0 ploda3=0 plodb1=16n \
        plodb2=0 plodb3=0 nf_flag=1 smbt=1M smbb=1M dinsaflag=0 ppitch=0 \
        spot=103n spob=103n spotl1=103n spobl1=103n spotl2=103n \
        spobl2=103n spotr1=103n spobr1=103n spotr2=103n spobr2=103n
U397 (VDLY CODE397 VDLY VSS) nch_svt_mac l=16n nfin=2 w=58n multi=1 nf=8 \
        sd=74n sa=90n sb=90n ploda1=16n ploda2=0 ploda3=0 plodb1=16n \
        plodb2=0 plodb3=0 nf_flag=1 smbt=1M smbb=1M dinsaflag=0 ppitch=0 \
        spot=103n spob=103n spotl1=103n spobl1=103n spotl2=103n \
        spobl2=103n spotr1=103n spobr1=103n spotr2=103n spobr2=103n
U396 (VDLY CODE396 VDLY VSS) nch_svt_mac l=16n nfin=2 w=58n multi=1 nf=8 \
        sd=74n sa=90n sb=90n ploda1=16n ploda2=0 ploda3=0 plodb1=16n \
        plodb2=0 plodb3=0 nf_flag=1 smbt=1M smbb=1M dinsaflag=0 ppitch=0 \
        spot=103n spob=103n spotl1=103n spobl1=103n spotl2=103n \
        spobl2=103n spotr1=103n spobr1=103n spotr2=103n spobr2=103n
U395 (VDLY CODE395 VDLY VSS) nch_svt_mac l=16n nfin=2 w=58n multi=1 nf=8 \
        sd=74n sa=90n sb=90n ploda1=16n ploda2=0 ploda3=0 plodb1=16n \
        plodb2=0 plodb3=0 nf_flag=1 smbt=1M smbb=1M dinsaflag=0 ppitch=0 \
        spot=103n spob=103n spotl1=103n spobl1=103n spotl2=103n \
        spobl2=103n spotr1=103n spobr1=103n spotr2=103n spobr2=103n
U394 (VDLY CODE394 VDLY VSS) nch_svt_mac l=16n nfin=2 w=58n multi=1 nf=8 \
        sd=74n sa=90n sb=90n ploda1=16n ploda2=0 ploda3=0 plodb1=16n \
        plodb2=0 plodb3=0 nf_flag=1 smbt=1M smbb=1M dinsaflag=0 ppitch=0 \
        spot=103n spob=103n spotl1=103n spobl1=103n spotl2=103n \
        spobl2=103n spotr1=103n spobr1=103n spotr2=103n spobr2=103n
U393 (VDLY CODE393 VDLY VSS) nch_svt_mac l=16n nfin=2 w=58n multi=1 nf=8 \
        sd=74n sa=90n sb=90n ploda1=16n ploda2=0 ploda3=0 plodb1=16n \
        plodb2=0 plodb3=0 nf_flag=1 smbt=1M smbb=1M dinsaflag=0 ppitch=0 \
        spot=103n spob=103n spotl1=103n spobl1=103n spotl2=103n \
        spobl2=103n spotr1=103n spobr1=103n spotr2=103n spobr2=103n
U392 (VDLY CODE392 VDLY VSS) nch_svt_mac l=16n nfin=2 w=58n multi=1 nf=8 \
        sd=74n sa=90n sb=90n ploda1=16n ploda2=0 ploda3=0 plodb1=16n \
        plodb2=0 plodb3=0 nf_flag=1 smbt=1M smbb=1M dinsaflag=0 ppitch=0 \
        spot=103n spob=103n spotl1=103n spobl1=103n spotl2=103n \
        spobl2=103n spotr1=103n spobr1=103n spotr2=103n spobr2=103n
U391 (VDLY CODE391 VDLY VSS) nch_svt_mac l=16n nfin=2 w=58n multi=1 nf=8 \
        sd=74n sa=90n sb=90n ploda1=16n ploda2=0 ploda3=0 plodb1=16n \
        plodb2=0 plodb3=0 nf_flag=1 smbt=1M smbb=1M dinsaflag=0 ppitch=0 \
        spot=103n spob=103n spotl1=103n spobl1=103n spotl2=103n \
        spobl2=103n spotr1=103n spobr1=103n spotr2=103n spobr2=103n
U390 (VDLY CODE390 VDLY VSS) nch_svt_mac l=16n nfin=2 w=58n multi=1 nf=8 \
        sd=74n sa=90n sb=90n ploda1=16n ploda2=0 ploda3=0 plodb1=16n \
        plodb2=0 plodb3=0 nf_flag=1 smbt=1M smbb=1M dinsaflag=0 ppitch=0 \
        spot=103n spob=103n spotl1=103n spobl1=103n spotl2=103n \
        spobl2=103n spotr1=103n spobr1=103n spotr2=103n spobr2=103n
U389 (VDLY CODE389 VDLY VSS) nch_svt_mac l=16n nfin=2 w=58n multi=1 nf=8 \
        sd=74n sa=90n sb=90n ploda1=16n ploda2=0 ploda3=0 plodb1=16n \
        plodb2=0 plodb3=0 nf_flag=1 smbt=1M smbb=1M dinsaflag=0 ppitch=0 \
        spot=103n spob=103n spotl1=103n spobl1=103n spotl2=103n \
        spobl2=103n spotr1=103n spobr1=103n spotr2=103n spobr2=103n
U388 (VDLY CODE388 VDLY VSS) nch_svt_mac l=16n nfin=2 w=58n multi=1 nf=8 \
        sd=74n sa=90n sb=90n ploda1=16n ploda2=0 ploda3=0 plodb1=16n \
        plodb2=0 plodb3=0 nf_flag=1 smbt=1M smbb=1M dinsaflag=0 ppitch=0 \
        spot=103n spob=103n spotl1=103n spobl1=103n spotl2=103n \
        spobl2=103n spotr1=103n spobr1=103n spotr2=103n spobr2=103n
U387 (VDLY CODE387 VDLY VSS) nch_svt_mac l=16n nfin=2 w=58n multi=1 nf=8 \
        sd=74n sa=90n sb=90n ploda1=16n ploda2=0 ploda3=0 plodb1=16n \
        plodb2=0 plodb3=0 nf_flag=1 smbt=1M smbb=1M dinsaflag=0 ppitch=0 \
        spot=103n spob=103n spotl1=103n spobl1=103n spotl2=103n \
        spobl2=103n spotr1=103n spobr1=103n spotr2=103n spobr2=103n
U386 (VDLY CODE386 VDLY VSS) nch_svt_mac l=16n nfin=2 w=58n multi=1 nf=8 \
        sd=74n sa=90n sb=90n ploda1=16n ploda2=0 ploda3=0 plodb1=16n \
        plodb2=0 plodb3=0 nf_flag=1 smbt=1M smbb=1M dinsaflag=0 ppitch=0 \
        spot=103n spob=103n spotl1=103n spobl1=103n spotl2=103n \
        spobl2=103n spotr1=103n spobr1=103n spotr2=103n spobr2=103n
U385 (VDLY CODE385 VDLY VSS) nch_svt_mac l=16n nfin=2 w=58n multi=1 nf=8 \
        sd=74n sa=90n sb=90n ploda1=16n ploda2=0 ploda3=0 plodb1=16n \
        plodb2=0 plodb3=0 nf_flag=1 smbt=1M smbb=1M dinsaflag=0 ppitch=0 \
        spot=103n spob=103n spotl1=103n spobl1=103n spotl2=103n \
        spobl2=103n spotr1=103n spobr1=103n spotr2=103n spobr2=103n
U384 (VDLY CODE384 VDLY VSS) nch_svt_mac l=16n nfin=2 w=58n multi=1 nf=8 \
        sd=74n sa=90n sb=90n ploda1=16n ploda2=0 ploda3=0 plodb1=16n \
        plodb2=0 plodb3=0 nf_flag=1 smbt=1M smbb=1M dinsaflag=0 ppitch=0 \
        spot=103n spob=103n spotl1=103n spobl1=103n spotl2=103n \
        spobl2=103n spotr1=103n spobr1=103n spotr2=103n spobr2=103n
U383 (VDLY CODE383 VDLY VSS) nch_svt_mac l=16n nfin=2 w=58n multi=1 nf=8 \
        sd=74n sa=90n sb=90n ploda1=16n ploda2=0 ploda3=0 plodb1=16n \
        plodb2=0 plodb3=0 nf_flag=1 smbt=1M smbb=1M dinsaflag=0 ppitch=0 \
        spot=103n spob=103n spotl1=103n spobl1=103n spotl2=103n \
        spobl2=103n spotr1=103n spobr1=103n spotr2=103n spobr2=103n
U382 (VDLY CODE382 VDLY VSS) nch_svt_mac l=16n nfin=2 w=58n multi=1 nf=8 \
        sd=74n sa=90n sb=90n ploda1=16n ploda2=0 ploda3=0 plodb1=16n \
        plodb2=0 plodb3=0 nf_flag=1 smbt=1M smbb=1M dinsaflag=0 ppitch=0 \
        spot=103n spob=103n spotl1=103n spobl1=103n spotl2=103n \
        spobl2=103n spotr1=103n spobr1=103n spotr2=103n spobr2=103n
U381 (VDLY CODE381 VDLY VSS) nch_svt_mac l=16n nfin=2 w=58n multi=1 nf=8 \
        sd=74n sa=90n sb=90n ploda1=16n ploda2=0 ploda3=0 plodb1=16n \
        plodb2=0 plodb3=0 nf_flag=1 smbt=1M smbb=1M dinsaflag=0 ppitch=0 \
        spot=103n spob=103n spotl1=103n spobl1=103n spotl2=103n \
        spobl2=103n spotr1=103n spobr1=103n spotr2=103n spobr2=103n
U380 (VDLY CODE380 VDLY VSS) nch_svt_mac l=16n nfin=2 w=58n multi=1 nf=8 \
        sd=74n sa=90n sb=90n ploda1=16n ploda2=0 ploda3=0 plodb1=16n \
        plodb2=0 plodb3=0 nf_flag=1 smbt=1M smbb=1M dinsaflag=0 ppitch=0 \
        spot=103n spob=103n spotl1=103n spobl1=103n spotl2=103n \
        spobl2=103n spotr1=103n spobr1=103n spotr2=103n spobr2=103n
U379 (VDLY CODE379 VDLY VSS) nch_svt_mac l=16n nfin=2 w=58n multi=1 nf=8 \
        sd=74n sa=90n sb=90n ploda1=16n ploda2=0 ploda3=0 plodb1=16n \
        plodb2=0 plodb3=0 nf_flag=1 smbt=1M smbb=1M dinsaflag=0 ppitch=0 \
        spot=103n spob=103n spotl1=103n spobl1=103n spotl2=103n \
        spobl2=103n spotr1=103n spobr1=103n spotr2=103n spobr2=103n
U378 (VDLY CODE378 VDLY VSS) nch_svt_mac l=16n nfin=2 w=58n multi=1 nf=8 \
        sd=74n sa=90n sb=90n ploda1=16n ploda2=0 ploda3=0 plodb1=16n \
        plodb2=0 plodb3=0 nf_flag=1 smbt=1M smbb=1M dinsaflag=0 ppitch=0 \
        spot=103n spob=103n spotl1=103n spobl1=103n spotl2=103n \
        spobl2=103n spotr1=103n spobr1=103n spotr2=103n spobr2=103n
U377 (VDLY CODE377 VDLY VSS) nch_svt_mac l=16n nfin=2 w=58n multi=1 nf=8 \
        sd=74n sa=90n sb=90n ploda1=16n ploda2=0 ploda3=0 plodb1=16n \
        plodb2=0 plodb3=0 nf_flag=1 smbt=1M smbb=1M dinsaflag=0 ppitch=0 \
        spot=103n spob=103n spotl1=103n spobl1=103n spotl2=103n \
        spobl2=103n spotr1=103n spobr1=103n spotr2=103n spobr2=103n
U376 (VDLY CODE376 VDLY VSS) nch_svt_mac l=16n nfin=2 w=58n multi=1 nf=8 \
        sd=74n sa=90n sb=90n ploda1=16n ploda2=0 ploda3=0 plodb1=16n \
        plodb2=0 plodb3=0 nf_flag=1 smbt=1M smbb=1M dinsaflag=0 ppitch=0 \
        spot=103n spob=103n spotl1=103n spobl1=103n spotl2=103n \
        spobl2=103n spotr1=103n spobr1=103n spotr2=103n spobr2=103n
U375 (VDLY CODE375 VDLY VSS) nch_svt_mac l=16n nfin=2 w=58n multi=1 nf=8 \
        sd=74n sa=90n sb=90n ploda1=16n ploda2=0 ploda3=0 plodb1=16n \
        plodb2=0 plodb3=0 nf_flag=1 smbt=1M smbb=1M dinsaflag=0 ppitch=0 \
        spot=103n spob=103n spotl1=103n spobl1=103n spotl2=103n \
        spobl2=103n spotr1=103n spobr1=103n spotr2=103n spobr2=103n
U374 (VDLY CODE374 VDLY VSS) nch_svt_mac l=16n nfin=2 w=58n multi=1 nf=8 \
        sd=74n sa=90n sb=90n ploda1=16n ploda2=0 ploda3=0 plodb1=16n \
        plodb2=0 plodb3=0 nf_flag=1 smbt=1M smbb=1M dinsaflag=0 ppitch=0 \
        spot=103n spob=103n spotl1=103n spobl1=103n spotl2=103n \
        spobl2=103n spotr1=103n spobr1=103n spotr2=103n spobr2=103n
U373 (VDLY CODE373 VDLY VSS) nch_svt_mac l=16n nfin=2 w=58n multi=1 nf=8 \
        sd=74n sa=90n sb=90n ploda1=16n ploda2=0 ploda3=0 plodb1=16n \
        plodb2=0 plodb3=0 nf_flag=1 smbt=1M smbb=1M dinsaflag=0 ppitch=0 \
        spot=103n spob=103n spotl1=103n spobl1=103n spotl2=103n \
        spobl2=103n spotr1=103n spobr1=103n spotr2=103n spobr2=103n
U372 (VDLY CODE372 VDLY VSS) nch_svt_mac l=16n nfin=2 w=58n multi=1 nf=8 \
        sd=74n sa=90n sb=90n ploda1=16n ploda2=0 ploda3=0 plodb1=16n \
        plodb2=0 plodb3=0 nf_flag=1 smbt=1M smbb=1M dinsaflag=0 ppitch=0 \
        spot=103n spob=103n spotl1=103n spobl1=103n spotl2=103n \
        spobl2=103n spotr1=103n spobr1=103n spotr2=103n spobr2=103n
U371 (VDLY CODE371 VDLY VSS) nch_svt_mac l=16n nfin=2 w=58n multi=1 nf=8 \
        sd=74n sa=90n sb=90n ploda1=16n ploda2=0 ploda3=0 plodb1=16n \
        plodb2=0 plodb3=0 nf_flag=1 smbt=1M smbb=1M dinsaflag=0 ppitch=0 \
        spot=103n spob=103n spotl1=103n spobl1=103n spotl2=103n \
        spobl2=103n spotr1=103n spobr1=103n spotr2=103n spobr2=103n
U370 (VDLY CODE370 VDLY VSS) nch_svt_mac l=16n nfin=2 w=58n multi=1 nf=8 \
        sd=74n sa=90n sb=90n ploda1=16n ploda2=0 ploda3=0 plodb1=16n \
        plodb2=0 plodb3=0 nf_flag=1 smbt=1M smbb=1M dinsaflag=0 ppitch=0 \
        spot=103n spob=103n spotl1=103n spobl1=103n spotl2=103n \
        spobl2=103n spotr1=103n spobr1=103n spotr2=103n spobr2=103n
U369 (VDLY CODE369 VDLY VSS) nch_svt_mac l=16n nfin=2 w=58n multi=1 nf=8 \
        sd=74n sa=90n sb=90n ploda1=16n ploda2=0 ploda3=0 plodb1=16n \
        plodb2=0 plodb3=0 nf_flag=1 smbt=1M smbb=1M dinsaflag=0 ppitch=0 \
        spot=103n spob=103n spotl1=103n spobl1=103n spotl2=103n \
        spobl2=103n spotr1=103n spobr1=103n spotr2=103n spobr2=103n
U368 (VDLY CODE368 VDLY VSS) nch_svt_mac l=16n nfin=2 w=58n multi=1 nf=8 \
        sd=74n sa=90n sb=90n ploda1=16n ploda2=0 ploda3=0 plodb1=16n \
        plodb2=0 plodb3=0 nf_flag=1 smbt=1M smbb=1M dinsaflag=0 ppitch=0 \
        spot=103n spob=103n spotl1=103n spobl1=103n spotl2=103n \
        spobl2=103n spotr1=103n spobr1=103n spotr2=103n spobr2=103n
U367 (VDLY CODE367 VDLY VSS) nch_svt_mac l=16n nfin=2 w=58n multi=1 nf=8 \
        sd=74n sa=90n sb=90n ploda1=16n ploda2=0 ploda3=0 plodb1=16n \
        plodb2=0 plodb3=0 nf_flag=1 smbt=1M smbb=1M dinsaflag=0 ppitch=0 \
        spot=103n spob=103n spotl1=103n spobl1=103n spotl2=103n \
        spobl2=103n spotr1=103n spobr1=103n spotr2=103n spobr2=103n
U366 (VDLY CODE366 VDLY VSS) nch_svt_mac l=16n nfin=2 w=58n multi=1 nf=8 \
        sd=74n sa=90n sb=90n ploda1=16n ploda2=0 ploda3=0 plodb1=16n \
        plodb2=0 plodb3=0 nf_flag=1 smbt=1M smbb=1M dinsaflag=0 ppitch=0 \
        spot=103n spob=103n spotl1=103n spobl1=103n spotl2=103n \
        spobl2=103n spotr1=103n spobr1=103n spotr2=103n spobr2=103n
U365 (VDLY CODE365 VDLY VSS) nch_svt_mac l=16n nfin=2 w=58n multi=1 nf=8 \
        sd=74n sa=90n sb=90n ploda1=16n ploda2=0 ploda3=0 plodb1=16n \
        plodb2=0 plodb3=0 nf_flag=1 smbt=1M smbb=1M dinsaflag=0 ppitch=0 \
        spot=103n spob=103n spotl1=103n spobl1=103n spotl2=103n \
        spobl2=103n spotr1=103n spobr1=103n spotr2=103n spobr2=103n
U364 (VDLY CODE364 VDLY VSS) nch_svt_mac l=16n nfin=2 w=58n multi=1 nf=8 \
        sd=74n sa=90n sb=90n ploda1=16n ploda2=0 ploda3=0 plodb1=16n \
        plodb2=0 plodb3=0 nf_flag=1 smbt=1M smbb=1M dinsaflag=0 ppitch=0 \
        spot=103n spob=103n spotl1=103n spobl1=103n spotl2=103n \
        spobl2=103n spotr1=103n spobr1=103n spotr2=103n spobr2=103n
U363 (VDLY CODE363 VDLY VSS) nch_svt_mac l=16n nfin=2 w=58n multi=1 nf=8 \
        sd=74n sa=90n sb=90n ploda1=16n ploda2=0 ploda3=0 plodb1=16n \
        plodb2=0 plodb3=0 nf_flag=1 smbt=1M smbb=1M dinsaflag=0 ppitch=0 \
        spot=103n spob=103n spotl1=103n spobl1=103n spotl2=103n \
        spobl2=103n spotr1=103n spobr1=103n spotr2=103n spobr2=103n
U362 (VDLY CODE362 VDLY VSS) nch_svt_mac l=16n nfin=2 w=58n multi=1 nf=8 \
        sd=74n sa=90n sb=90n ploda1=16n ploda2=0 ploda3=0 plodb1=16n \
        plodb2=0 plodb3=0 nf_flag=1 smbt=1M smbb=1M dinsaflag=0 ppitch=0 \
        spot=103n spob=103n spotl1=103n spobl1=103n spotl2=103n \
        spobl2=103n spotr1=103n spobr1=103n spotr2=103n spobr2=103n
U361 (VDLY CODE361 VDLY VSS) nch_svt_mac l=16n nfin=2 w=58n multi=1 nf=8 \
        sd=74n sa=90n sb=90n ploda1=16n ploda2=0 ploda3=0 plodb1=16n \
        plodb2=0 plodb3=0 nf_flag=1 smbt=1M smbb=1M dinsaflag=0 ppitch=0 \
        spot=103n spob=103n spotl1=103n spobl1=103n spotl2=103n \
        spobl2=103n spotr1=103n spobr1=103n spotr2=103n spobr2=103n
U360 (VDLY CODE360 VDLY VSS) nch_svt_mac l=16n nfin=2 w=58n multi=1 nf=8 \
        sd=74n sa=90n sb=90n ploda1=16n ploda2=0 ploda3=0 plodb1=16n \
        plodb2=0 plodb3=0 nf_flag=1 smbt=1M smbb=1M dinsaflag=0 ppitch=0 \
        spot=103n spob=103n spotl1=103n spobl1=103n spotl2=103n \
        spobl2=103n spotr1=103n spobr1=103n spotr2=103n spobr2=103n
U359 (VDLY CODE359 VDLY VSS) nch_svt_mac l=16n nfin=2 w=58n multi=1 nf=8 \
        sd=74n sa=90n sb=90n ploda1=16n ploda2=0 ploda3=0 plodb1=16n \
        plodb2=0 plodb3=0 nf_flag=1 smbt=1M smbb=1M dinsaflag=0 ppitch=0 \
        spot=103n spob=103n spotl1=103n spobl1=103n spotl2=103n \
        spobl2=103n spotr1=103n spobr1=103n spotr2=103n spobr2=103n
U358 (VDLY CODE358 VDLY VSS) nch_svt_mac l=16n nfin=2 w=58n multi=1 nf=8 \
        sd=74n sa=90n sb=90n ploda1=16n ploda2=0 ploda3=0 plodb1=16n \
        plodb2=0 plodb3=0 nf_flag=1 smbt=1M smbb=1M dinsaflag=0 ppitch=0 \
        spot=103n spob=103n spotl1=103n spobl1=103n spotl2=103n \
        spobl2=103n spotr1=103n spobr1=103n spotr2=103n spobr2=103n
U357 (VDLY CODE357 VDLY VSS) nch_svt_mac l=16n nfin=2 w=58n multi=1 nf=8 \
        sd=74n sa=90n sb=90n ploda1=16n ploda2=0 ploda3=0 plodb1=16n \
        plodb2=0 plodb3=0 nf_flag=1 smbt=1M smbb=1M dinsaflag=0 ppitch=0 \
        spot=103n spob=103n spotl1=103n spobl1=103n spotl2=103n \
        spobl2=103n spotr1=103n spobr1=103n spotr2=103n spobr2=103n
U356 (VDLY CODE356 VDLY VSS) nch_svt_mac l=16n nfin=2 w=58n multi=1 nf=8 \
        sd=74n sa=90n sb=90n ploda1=16n ploda2=0 ploda3=0 plodb1=16n \
        plodb2=0 plodb3=0 nf_flag=1 smbt=1M smbb=1M dinsaflag=0 ppitch=0 \
        spot=103n spob=103n spotl1=103n spobl1=103n spotl2=103n \
        spobl2=103n spotr1=103n spobr1=103n spotr2=103n spobr2=103n
U355 (VDLY CODE355 VDLY VSS) nch_svt_mac l=16n nfin=2 w=58n multi=1 nf=8 \
        sd=74n sa=90n sb=90n ploda1=16n ploda2=0 ploda3=0 plodb1=16n \
        plodb2=0 plodb3=0 nf_flag=1 smbt=1M smbb=1M dinsaflag=0 ppitch=0 \
        spot=103n spob=103n spotl1=103n spobl1=103n spotl2=103n \
        spobl2=103n spotr1=103n spobr1=103n spotr2=103n spobr2=103n
U354 (VDLY CODE354 VDLY VSS) nch_svt_mac l=16n nfin=2 w=58n multi=1 nf=8 \
        sd=74n sa=90n sb=90n ploda1=16n ploda2=0 ploda3=0 plodb1=16n \
        plodb2=0 plodb3=0 nf_flag=1 smbt=1M smbb=1M dinsaflag=0 ppitch=0 \
        spot=103n spob=103n spotl1=103n spobl1=103n spotl2=103n \
        spobl2=103n spotr1=103n spobr1=103n spotr2=103n spobr2=103n
U353 (VDLY CODE353 VDLY VSS) nch_svt_mac l=16n nfin=2 w=58n multi=1 nf=8 \
        sd=74n sa=90n sb=90n ploda1=16n ploda2=0 ploda3=0 plodb1=16n \
        plodb2=0 plodb3=0 nf_flag=1 smbt=1M smbb=1M dinsaflag=0 ppitch=0 \
        spot=103n spob=103n spotl1=103n spobl1=103n spotl2=103n \
        spobl2=103n spotr1=103n spobr1=103n spotr2=103n spobr2=103n
U352 (VDLY CODE352 VDLY VSS) nch_svt_mac l=16n nfin=2 w=58n multi=1 nf=8 \
        sd=74n sa=90n sb=90n ploda1=16n ploda2=0 ploda3=0 plodb1=16n \
        plodb2=0 plodb3=0 nf_flag=1 smbt=1M smbb=1M dinsaflag=0 ppitch=0 \
        spot=103n spob=103n spotl1=103n spobl1=103n spotl2=103n \
        spobl2=103n spotr1=103n spobr1=103n spotr2=103n spobr2=103n
U351 (VDLY CODE351 VDLY VSS) nch_svt_mac l=16n nfin=2 w=58n multi=1 nf=8 \
        sd=74n sa=90n sb=90n ploda1=16n ploda2=0 ploda3=0 plodb1=16n \
        plodb2=0 plodb3=0 nf_flag=1 smbt=1M smbb=1M dinsaflag=0 ppitch=0 \
        spot=103n spob=103n spotl1=103n spobl1=103n spotl2=103n \
        spobl2=103n spotr1=103n spobr1=103n spotr2=103n spobr2=103n
U350 (VDLY CODE350 VDLY VSS) nch_svt_mac l=16n nfin=2 w=58n multi=1 nf=8 \
        sd=74n sa=90n sb=90n ploda1=16n ploda2=0 ploda3=0 plodb1=16n \
        plodb2=0 plodb3=0 nf_flag=1 smbt=1M smbb=1M dinsaflag=0 ppitch=0 \
        spot=103n spob=103n spotl1=103n spobl1=103n spotl2=103n \
        spobl2=103n spotr1=103n spobr1=103n spotr2=103n spobr2=103n
U349 (VDLY CODE349 VDLY VSS) nch_svt_mac l=16n nfin=2 w=58n multi=1 nf=8 \
        sd=74n sa=90n sb=90n ploda1=16n ploda2=0 ploda3=0 plodb1=16n \
        plodb2=0 plodb3=0 nf_flag=1 smbt=1M smbb=1M dinsaflag=0 ppitch=0 \
        spot=103n spob=103n spotl1=103n spobl1=103n spotl2=103n \
        spobl2=103n spotr1=103n spobr1=103n spotr2=103n spobr2=103n
U348 (VDLY CODE348 VDLY VSS) nch_svt_mac l=16n nfin=2 w=58n multi=1 nf=8 \
        sd=74n sa=90n sb=90n ploda1=16n ploda2=0 ploda3=0 plodb1=16n \
        plodb2=0 plodb3=0 nf_flag=1 smbt=1M smbb=1M dinsaflag=0 ppitch=0 \
        spot=103n spob=103n spotl1=103n spobl1=103n spotl2=103n \
        spobl2=103n spotr1=103n spobr1=103n spotr2=103n spobr2=103n
U347 (VDLY CODE347 VDLY VSS) nch_svt_mac l=16n nfin=2 w=58n multi=1 nf=8 \
        sd=74n sa=90n sb=90n ploda1=16n ploda2=0 ploda3=0 plodb1=16n \
        plodb2=0 plodb3=0 nf_flag=1 smbt=1M smbb=1M dinsaflag=0 ppitch=0 \
        spot=103n spob=103n spotl1=103n spobl1=103n spotl2=103n \
        spobl2=103n spotr1=103n spobr1=103n spotr2=103n spobr2=103n
U346 (VDLY CODE346 VDLY VSS) nch_svt_mac l=16n nfin=2 w=58n multi=1 nf=8 \
        sd=74n sa=90n sb=90n ploda1=16n ploda2=0 ploda3=0 plodb1=16n \
        plodb2=0 plodb3=0 nf_flag=1 smbt=1M smbb=1M dinsaflag=0 ppitch=0 \
        spot=103n spob=103n spotl1=103n spobl1=103n spotl2=103n \
        spobl2=103n spotr1=103n spobr1=103n spotr2=103n spobr2=103n
U345 (VDLY CODE345 VDLY VSS) nch_svt_mac l=16n nfin=2 w=58n multi=1 nf=8 \
        sd=74n sa=90n sb=90n ploda1=16n ploda2=0 ploda3=0 plodb1=16n \
        plodb2=0 plodb3=0 nf_flag=1 smbt=1M smbb=1M dinsaflag=0 ppitch=0 \
        spot=103n spob=103n spotl1=103n spobl1=103n spotl2=103n \
        spobl2=103n spotr1=103n spobr1=103n spotr2=103n spobr2=103n
U344 (VDLY CODE344 VDLY VSS) nch_svt_mac l=16n nfin=2 w=58n multi=1 nf=8 \
        sd=74n sa=90n sb=90n ploda1=16n ploda2=0 ploda3=0 plodb1=16n \
        plodb2=0 plodb3=0 nf_flag=1 smbt=1M smbb=1M dinsaflag=0 ppitch=0 \
        spot=103n spob=103n spotl1=103n spobl1=103n spotl2=103n \
        spobl2=103n spotr1=103n spobr1=103n spotr2=103n spobr2=103n
U343 (VDLY CODE343 VDLY VSS) nch_svt_mac l=16n nfin=2 w=58n multi=1 nf=8 \
        sd=74n sa=90n sb=90n ploda1=16n ploda2=0 ploda3=0 plodb1=16n \
        plodb2=0 plodb3=0 nf_flag=1 smbt=1M smbb=1M dinsaflag=0 ppitch=0 \
        spot=103n spob=103n spotl1=103n spobl1=103n spotl2=103n \
        spobl2=103n spotr1=103n spobr1=103n spotr2=103n spobr2=103n
U342 (VDLY CODE342 VDLY VSS) nch_svt_mac l=16n nfin=2 w=58n multi=1 nf=8 \
        sd=74n sa=90n sb=90n ploda1=16n ploda2=0 ploda3=0 plodb1=16n \
        plodb2=0 plodb3=0 nf_flag=1 smbt=1M smbb=1M dinsaflag=0 ppitch=0 \
        spot=103n spob=103n spotl1=103n spobl1=103n spotl2=103n \
        spobl2=103n spotr1=103n spobr1=103n spotr2=103n spobr2=103n
U341 (VDLY CODE341 VDLY VSS) nch_svt_mac l=16n nfin=2 w=58n multi=1 nf=8 \
        sd=74n sa=90n sb=90n ploda1=16n ploda2=0 ploda3=0 plodb1=16n \
        plodb2=0 plodb3=0 nf_flag=1 smbt=1M smbb=1M dinsaflag=0 ppitch=0 \
        spot=103n spob=103n spotl1=103n spobl1=103n spotl2=103n \
        spobl2=103n spotr1=103n spobr1=103n spotr2=103n spobr2=103n
U340 (VDLY CODE340 VDLY VSS) nch_svt_mac l=16n nfin=2 w=58n multi=1 nf=8 \
        sd=74n sa=90n sb=90n ploda1=16n ploda2=0 ploda3=0 plodb1=16n \
        plodb2=0 plodb3=0 nf_flag=1 smbt=1M smbb=1M dinsaflag=0 ppitch=0 \
        spot=103n spob=103n spotl1=103n spobl1=103n spotl2=103n \
        spobl2=103n spotr1=103n spobr1=103n spotr2=103n spobr2=103n
U339 (VDLY CODE339 VDLY VSS) nch_svt_mac l=16n nfin=2 w=58n multi=1 nf=8 \
        sd=74n sa=90n sb=90n ploda1=16n ploda2=0 ploda3=0 plodb1=16n \
        plodb2=0 plodb3=0 nf_flag=1 smbt=1M smbb=1M dinsaflag=0 ppitch=0 \
        spot=103n spob=103n spotl1=103n spobl1=103n spotl2=103n \
        spobl2=103n spotr1=103n spobr1=103n spotr2=103n spobr2=103n
U338 (VDLY CODE338 VDLY VSS) nch_svt_mac l=16n nfin=2 w=58n multi=1 nf=8 \
        sd=74n sa=90n sb=90n ploda1=16n ploda2=0 ploda3=0 plodb1=16n \
        plodb2=0 plodb3=0 nf_flag=1 smbt=1M smbb=1M dinsaflag=0 ppitch=0 \
        spot=103n spob=103n spotl1=103n spobl1=103n spotl2=103n \
        spobl2=103n spotr1=103n spobr1=103n spotr2=103n spobr2=103n
U337 (VDLY CODE337 VDLY VSS) nch_svt_mac l=16n nfin=2 w=58n multi=1 nf=8 \
        sd=74n sa=90n sb=90n ploda1=16n ploda2=0 ploda3=0 plodb1=16n \
        plodb2=0 plodb3=0 nf_flag=1 smbt=1M smbb=1M dinsaflag=0 ppitch=0 \
        spot=103n spob=103n spotl1=103n spobl1=103n spotl2=103n \
        spobl2=103n spotr1=103n spobr1=103n spotr2=103n spobr2=103n
U336 (VDLY CODE336 VDLY VSS) nch_svt_mac l=16n nfin=2 w=58n multi=1 nf=8 \
        sd=74n sa=90n sb=90n ploda1=16n ploda2=0 ploda3=0 plodb1=16n \
        plodb2=0 plodb3=0 nf_flag=1 smbt=1M smbb=1M dinsaflag=0 ppitch=0 \
        spot=103n spob=103n spotl1=103n spobl1=103n spotl2=103n \
        spobl2=103n spotr1=103n spobr1=103n spotr2=103n spobr2=103n
U335 (VDLY CODE335 VDLY VSS) nch_svt_mac l=16n nfin=2 w=58n multi=1 nf=8 \
        sd=74n sa=90n sb=90n ploda1=16n ploda2=0 ploda3=0 plodb1=16n \
        plodb2=0 plodb3=0 nf_flag=1 smbt=1M smbb=1M dinsaflag=0 ppitch=0 \
        spot=103n spob=103n spotl1=103n spobl1=103n spotl2=103n \
        spobl2=103n spotr1=103n spobr1=103n spotr2=103n spobr2=103n
U334 (VDLY CODE334 VDLY VSS) nch_svt_mac l=16n nfin=2 w=58n multi=1 nf=8 \
        sd=74n sa=90n sb=90n ploda1=16n ploda2=0 ploda3=0 plodb1=16n \
        plodb2=0 plodb3=0 nf_flag=1 smbt=1M smbb=1M dinsaflag=0 ppitch=0 \
        spot=103n spob=103n spotl1=103n spobl1=103n spotl2=103n \
        spobl2=103n spotr1=103n spobr1=103n spotr2=103n spobr2=103n
U333 (VDLY CODE333 VDLY VSS) nch_svt_mac l=16n nfin=2 w=58n multi=1 nf=8 \
        sd=74n sa=90n sb=90n ploda1=16n ploda2=0 ploda3=0 plodb1=16n \
        plodb2=0 plodb3=0 nf_flag=1 smbt=1M smbb=1M dinsaflag=0 ppitch=0 \
        spot=103n spob=103n spotl1=103n spobl1=103n spotl2=103n \
        spobl2=103n spotr1=103n spobr1=103n spotr2=103n spobr2=103n
U332 (VDLY CODE332 VDLY VSS) nch_svt_mac l=16n nfin=2 w=58n multi=1 nf=8 \
        sd=74n sa=90n sb=90n ploda1=16n ploda2=0 ploda3=0 plodb1=16n \
        plodb2=0 plodb3=0 nf_flag=1 smbt=1M smbb=1M dinsaflag=0 ppitch=0 \
        spot=103n spob=103n spotl1=103n spobl1=103n spotl2=103n \
        spobl2=103n spotr1=103n spobr1=103n spotr2=103n spobr2=103n
U331 (VDLY CODE331 VDLY VSS) nch_svt_mac l=16n nfin=2 w=58n multi=1 nf=8 \
        sd=74n sa=90n sb=90n ploda1=16n ploda2=0 ploda3=0 plodb1=16n \
        plodb2=0 plodb3=0 nf_flag=1 smbt=1M smbb=1M dinsaflag=0 ppitch=0 \
        spot=103n spob=103n spotl1=103n spobl1=103n spotl2=103n \
        spobl2=103n spotr1=103n spobr1=103n spotr2=103n spobr2=103n
U330 (VDLY CODE330 VDLY VSS) nch_svt_mac l=16n nfin=2 w=58n multi=1 nf=8 \
        sd=74n sa=90n sb=90n ploda1=16n ploda2=0 ploda3=0 plodb1=16n \
        plodb2=0 plodb3=0 nf_flag=1 smbt=1M smbb=1M dinsaflag=0 ppitch=0 \
        spot=103n spob=103n spotl1=103n spobl1=103n spotl2=103n \
        spobl2=103n spotr1=103n spobr1=103n spotr2=103n spobr2=103n
U329 (VDLY CODE329 VDLY VSS) nch_svt_mac l=16n nfin=2 w=58n multi=1 nf=8 \
        sd=74n sa=90n sb=90n ploda1=16n ploda2=0 ploda3=0 plodb1=16n \
        plodb2=0 plodb3=0 nf_flag=1 smbt=1M smbb=1M dinsaflag=0 ppitch=0 \
        spot=103n spob=103n spotl1=103n spobl1=103n spotl2=103n \
        spobl2=103n spotr1=103n spobr1=103n spotr2=103n spobr2=103n
U328 (VDLY CODE328 VDLY VSS) nch_svt_mac l=16n nfin=2 w=58n multi=1 nf=8 \
        sd=74n sa=90n sb=90n ploda1=16n ploda2=0 ploda3=0 plodb1=16n \
        plodb2=0 plodb3=0 nf_flag=1 smbt=1M smbb=1M dinsaflag=0 ppitch=0 \
        spot=103n spob=103n spotl1=103n spobl1=103n spotl2=103n \
        spobl2=103n spotr1=103n spobr1=103n spotr2=103n spobr2=103n
U327 (VDLY CODE327 VDLY VSS) nch_svt_mac l=16n nfin=2 w=58n multi=1 nf=8 \
        sd=74n sa=90n sb=90n ploda1=16n ploda2=0 ploda3=0 plodb1=16n \
        plodb2=0 plodb3=0 nf_flag=1 smbt=1M smbb=1M dinsaflag=0 ppitch=0 \
        spot=103n spob=103n spotl1=103n spobl1=103n spotl2=103n \
        spobl2=103n spotr1=103n spobr1=103n spotr2=103n spobr2=103n
U326 (VDLY CODE326 VDLY VSS) nch_svt_mac l=16n nfin=2 w=58n multi=1 nf=8 \
        sd=74n sa=90n sb=90n ploda1=16n ploda2=0 ploda3=0 plodb1=16n \
        plodb2=0 plodb3=0 nf_flag=1 smbt=1M smbb=1M dinsaflag=0 ppitch=0 \
        spot=103n spob=103n spotl1=103n spobl1=103n spotl2=103n \
        spobl2=103n spotr1=103n spobr1=103n spotr2=103n spobr2=103n
U325 (VDLY CODE325 VDLY VSS) nch_svt_mac l=16n nfin=2 w=58n multi=1 nf=8 \
        sd=74n sa=90n sb=90n ploda1=16n ploda2=0 ploda3=0 plodb1=16n \
        plodb2=0 plodb3=0 nf_flag=1 smbt=1M smbb=1M dinsaflag=0 ppitch=0 \
        spot=103n spob=103n spotl1=103n spobl1=103n spotl2=103n \
        spobl2=103n spotr1=103n spobr1=103n spotr2=103n spobr2=103n
U324 (VDLY CODE324 VDLY VSS) nch_svt_mac l=16n nfin=2 w=58n multi=1 nf=8 \
        sd=74n sa=90n sb=90n ploda1=16n ploda2=0 ploda3=0 plodb1=16n \
        plodb2=0 plodb3=0 nf_flag=1 smbt=1M smbb=1M dinsaflag=0 ppitch=0 \
        spot=103n spob=103n spotl1=103n spobl1=103n spotl2=103n \
        spobl2=103n spotr1=103n spobr1=103n spotr2=103n spobr2=103n
U323 (VDLY CODE323 VDLY VSS) nch_svt_mac l=16n nfin=2 w=58n multi=1 nf=8 \
        sd=74n sa=90n sb=90n ploda1=16n ploda2=0 ploda3=0 plodb1=16n \
        plodb2=0 plodb3=0 nf_flag=1 smbt=1M smbb=1M dinsaflag=0 ppitch=0 \
        spot=103n spob=103n spotl1=103n spobl1=103n spotl2=103n \
        spobl2=103n spotr1=103n spobr1=103n spotr2=103n spobr2=103n
U322 (VDLY CODE322 VDLY VSS) nch_svt_mac l=16n nfin=2 w=58n multi=1 nf=8 \
        sd=74n sa=90n sb=90n ploda1=16n ploda2=0 ploda3=0 plodb1=16n \
        plodb2=0 plodb3=0 nf_flag=1 smbt=1M smbb=1M dinsaflag=0 ppitch=0 \
        spot=103n spob=103n spotl1=103n spobl1=103n spotl2=103n \
        spobl2=103n spotr1=103n spobr1=103n spotr2=103n spobr2=103n
U321 (VDLY CODE321 VDLY VSS) nch_svt_mac l=16n nfin=2 w=58n multi=1 nf=8 \
        sd=74n sa=90n sb=90n ploda1=16n ploda2=0 ploda3=0 plodb1=16n \
        plodb2=0 plodb3=0 nf_flag=1 smbt=1M smbb=1M dinsaflag=0 ppitch=0 \
        spot=103n spob=103n spotl1=103n spobl1=103n spotl2=103n \
        spobl2=103n spotr1=103n spobr1=103n spotr2=103n spobr2=103n
U320 (VDLY CODE320 VDLY VSS) nch_svt_mac l=16n nfin=2 w=58n multi=1 nf=8 \
        sd=74n sa=90n sb=90n ploda1=16n ploda2=0 ploda3=0 plodb1=16n \
        plodb2=0 plodb3=0 nf_flag=1 smbt=1M smbb=1M dinsaflag=0 ppitch=0 \
        spot=103n spob=103n spotl1=103n spobl1=103n spotl2=103n \
        spobl2=103n spotr1=103n spobr1=103n spotr2=103n spobr2=103n
U319 (VDLY CODE319 VDLY VSS) nch_svt_mac l=16n nfin=2 w=58n multi=1 nf=8 \
        sd=74n sa=90n sb=90n ploda1=16n ploda2=0 ploda3=0 plodb1=16n \
        plodb2=0 plodb3=0 nf_flag=1 smbt=1M smbb=1M dinsaflag=0 ppitch=0 \
        spot=103n spob=103n spotl1=103n spobl1=103n spotl2=103n \
        spobl2=103n spotr1=103n spobr1=103n spotr2=103n spobr2=103n
U318 (VDLY CODE318 VDLY VSS) nch_svt_mac l=16n nfin=2 w=58n multi=1 nf=8 \
        sd=74n sa=90n sb=90n ploda1=16n ploda2=0 ploda3=0 plodb1=16n \
        plodb2=0 plodb3=0 nf_flag=1 smbt=1M smbb=1M dinsaflag=0 ppitch=0 \
        spot=103n spob=103n spotl1=103n spobl1=103n spotl2=103n \
        spobl2=103n spotr1=103n spobr1=103n spotr2=103n spobr2=103n
U317 (VDLY CODE317 VDLY VSS) nch_svt_mac l=16n nfin=2 w=58n multi=1 nf=8 \
        sd=74n sa=90n sb=90n ploda1=16n ploda2=0 ploda3=0 plodb1=16n \
        plodb2=0 plodb3=0 nf_flag=1 smbt=1M smbb=1M dinsaflag=0 ppitch=0 \
        spot=103n spob=103n spotl1=103n spobl1=103n spotl2=103n \
        spobl2=103n spotr1=103n spobr1=103n spotr2=103n spobr2=103n
U316 (VDLY CODE316 VDLY VSS) nch_svt_mac l=16n nfin=2 w=58n multi=1 nf=8 \
        sd=74n sa=90n sb=90n ploda1=16n ploda2=0 ploda3=0 plodb1=16n \
        plodb2=0 plodb3=0 nf_flag=1 smbt=1M smbb=1M dinsaflag=0 ppitch=0 \
        spot=103n spob=103n spotl1=103n spobl1=103n spotl2=103n \
        spobl2=103n spotr1=103n spobr1=103n spotr2=103n spobr2=103n
U315 (VDLY CODE315 VDLY VSS) nch_svt_mac l=16n nfin=2 w=58n multi=1 nf=8 \
        sd=74n sa=90n sb=90n ploda1=16n ploda2=0 ploda3=0 plodb1=16n \
        plodb2=0 plodb3=0 nf_flag=1 smbt=1M smbb=1M dinsaflag=0 ppitch=0 \
        spot=103n spob=103n spotl1=103n spobl1=103n spotl2=103n \
        spobl2=103n spotr1=103n spobr1=103n spotr2=103n spobr2=103n
U314 (VDLY CODE314 VDLY VSS) nch_svt_mac l=16n nfin=2 w=58n multi=1 nf=8 \
        sd=74n sa=90n sb=90n ploda1=16n ploda2=0 ploda3=0 plodb1=16n \
        plodb2=0 plodb3=0 nf_flag=1 smbt=1M smbb=1M dinsaflag=0 ppitch=0 \
        spot=103n spob=103n spotl1=103n spobl1=103n spotl2=103n \
        spobl2=103n spotr1=103n spobr1=103n spotr2=103n spobr2=103n
U313 (VDLY CODE313 VDLY VSS) nch_svt_mac l=16n nfin=2 w=58n multi=1 nf=8 \
        sd=74n sa=90n sb=90n ploda1=16n ploda2=0 ploda3=0 plodb1=16n \
        plodb2=0 plodb3=0 nf_flag=1 smbt=1M smbb=1M dinsaflag=0 ppitch=0 \
        spot=103n spob=103n spotl1=103n spobl1=103n spotl2=103n \
        spobl2=103n spotr1=103n spobr1=103n spotr2=103n spobr2=103n
U312 (VDLY CODE312 VDLY VSS) nch_svt_mac l=16n nfin=2 w=58n multi=1 nf=8 \
        sd=74n sa=90n sb=90n ploda1=16n ploda2=0 ploda3=0 plodb1=16n \
        plodb2=0 plodb3=0 nf_flag=1 smbt=1M smbb=1M dinsaflag=0 ppitch=0 \
        spot=103n spob=103n spotl1=103n spobl1=103n spotl2=103n \
        spobl2=103n spotr1=103n spobr1=103n spotr2=103n spobr2=103n
U311 (VDLY CODE311 VDLY VSS) nch_svt_mac l=16n nfin=2 w=58n multi=1 nf=8 \
        sd=74n sa=90n sb=90n ploda1=16n ploda2=0 ploda3=0 plodb1=16n \
        plodb2=0 plodb3=0 nf_flag=1 smbt=1M smbb=1M dinsaflag=0 ppitch=0 \
        spot=103n spob=103n spotl1=103n spobl1=103n spotl2=103n \
        spobl2=103n spotr1=103n spobr1=103n spotr2=103n spobr2=103n
U310 (VDLY CODE310 VDLY VSS) nch_svt_mac l=16n nfin=2 w=58n multi=1 nf=8 \
        sd=74n sa=90n sb=90n ploda1=16n ploda2=0 ploda3=0 plodb1=16n \
        plodb2=0 plodb3=0 nf_flag=1 smbt=1M smbb=1M dinsaflag=0 ppitch=0 \
        spot=103n spob=103n spotl1=103n spobl1=103n spotl2=103n \
        spobl2=103n spotr1=103n spobr1=103n spotr2=103n spobr2=103n
U309 (VDLY CODE309 VDLY VSS) nch_svt_mac l=16n nfin=2 w=58n multi=1 nf=8 \
        sd=74n sa=90n sb=90n ploda1=16n ploda2=0 ploda3=0 plodb1=16n \
        plodb2=0 plodb3=0 nf_flag=1 smbt=1M smbb=1M dinsaflag=0 ppitch=0 \
        spot=103n spob=103n spotl1=103n spobl1=103n spotl2=103n \
        spobl2=103n spotr1=103n spobr1=103n spotr2=103n spobr2=103n
U308 (VDLY CODE308 VDLY VSS) nch_svt_mac l=16n nfin=2 w=58n multi=1 nf=8 \
        sd=74n sa=90n sb=90n ploda1=16n ploda2=0 ploda3=0 plodb1=16n \
        plodb2=0 plodb3=0 nf_flag=1 smbt=1M smbb=1M dinsaflag=0 ppitch=0 \
        spot=103n spob=103n spotl1=103n spobl1=103n spotl2=103n \
        spobl2=103n spotr1=103n spobr1=103n spotr2=103n spobr2=103n
U307 (VDLY CODE307 VDLY VSS) nch_svt_mac l=16n nfin=2 w=58n multi=1 nf=8 \
        sd=74n sa=90n sb=90n ploda1=16n ploda2=0 ploda3=0 plodb1=16n \
        plodb2=0 plodb3=0 nf_flag=1 smbt=1M smbb=1M dinsaflag=0 ppitch=0 \
        spot=103n spob=103n spotl1=103n spobl1=103n spotl2=103n \
        spobl2=103n spotr1=103n spobr1=103n spotr2=103n spobr2=103n
U306 (VDLY CODE306 VDLY VSS) nch_svt_mac l=16n nfin=2 w=58n multi=1 nf=8 \
        sd=74n sa=90n sb=90n ploda1=16n ploda2=0 ploda3=0 plodb1=16n \
        plodb2=0 plodb3=0 nf_flag=1 smbt=1M smbb=1M dinsaflag=0 ppitch=0 \
        spot=103n spob=103n spotl1=103n spobl1=103n spotl2=103n \
        spobl2=103n spotr1=103n spobr1=103n spotr2=103n spobr2=103n
U305 (VDLY CODE305 VDLY VSS) nch_svt_mac l=16n nfin=2 w=58n multi=1 nf=8 \
        sd=74n sa=90n sb=90n ploda1=16n ploda2=0 ploda3=0 plodb1=16n \
        plodb2=0 plodb3=0 nf_flag=1 smbt=1M smbb=1M dinsaflag=0 ppitch=0 \
        spot=103n spob=103n spotl1=103n spobl1=103n spotl2=103n \
        spobl2=103n spotr1=103n spobr1=103n spotr2=103n spobr2=103n
U304 (VDLY CODE304 VDLY VSS) nch_svt_mac l=16n nfin=2 w=58n multi=1 nf=8 \
        sd=74n sa=90n sb=90n ploda1=16n ploda2=0 ploda3=0 plodb1=16n \
        plodb2=0 plodb3=0 nf_flag=1 smbt=1M smbb=1M dinsaflag=0 ppitch=0 \
        spot=103n spob=103n spotl1=103n spobl1=103n spotl2=103n \
        spobl2=103n spotr1=103n spobr1=103n spotr2=103n spobr2=103n
U303 (VDLY CODE303 VDLY VSS) nch_svt_mac l=16n nfin=2 w=58n multi=1 nf=8 \
        sd=74n sa=90n sb=90n ploda1=16n ploda2=0 ploda3=0 plodb1=16n \
        plodb2=0 plodb3=0 nf_flag=1 smbt=1M smbb=1M dinsaflag=0 ppitch=0 \
        spot=103n spob=103n spotl1=103n spobl1=103n spotl2=103n \
        spobl2=103n spotr1=103n spobr1=103n spotr2=103n spobr2=103n
U302 (VDLY CODE302 VDLY VSS) nch_svt_mac l=16n nfin=2 w=58n multi=1 nf=8 \
        sd=74n sa=90n sb=90n ploda1=16n ploda2=0 ploda3=0 plodb1=16n \
        plodb2=0 plodb3=0 nf_flag=1 smbt=1M smbb=1M dinsaflag=0 ppitch=0 \
        spot=103n spob=103n spotl1=103n spobl1=103n spotl2=103n \
        spobl2=103n spotr1=103n spobr1=103n spotr2=103n spobr2=103n
U301 (VDLY CODE301 VDLY VSS) nch_svt_mac l=16n nfin=2 w=58n multi=1 nf=8 \
        sd=74n sa=90n sb=90n ploda1=16n ploda2=0 ploda3=0 plodb1=16n \
        plodb2=0 plodb3=0 nf_flag=1 smbt=1M smbb=1M dinsaflag=0 ppitch=0 \
        spot=103n spob=103n spotl1=103n spobl1=103n spotl2=103n \
        spobl2=103n spotr1=103n spobr1=103n spotr2=103n spobr2=103n
U300 (VDLY CODE300 VDLY VSS) nch_svt_mac l=16n nfin=2 w=58n multi=1 nf=8 \
        sd=74n sa=90n sb=90n ploda1=16n ploda2=0 ploda3=0 plodb1=16n \
        plodb2=0 plodb3=0 nf_flag=1 smbt=1M smbb=1M dinsaflag=0 ppitch=0 \
        spot=103n spob=103n spotl1=103n spobl1=103n spotl2=103n \
        spobl2=103n spotr1=103n spobr1=103n spotr2=103n spobr2=103n
U299 (VDLY CODE299 VDLY VSS) nch_svt_mac l=16n nfin=2 w=58n multi=1 nf=8 \
        sd=74n sa=90n sb=90n ploda1=16n ploda2=0 ploda3=0 plodb1=16n \
        plodb2=0 plodb3=0 nf_flag=1 smbt=1M smbb=1M dinsaflag=0 ppitch=0 \
        spot=103n spob=103n spotl1=103n spobl1=103n spotl2=103n \
        spobl2=103n spotr1=103n spobr1=103n spotr2=103n spobr2=103n
U298 (VDLY CODE298 VDLY VSS) nch_svt_mac l=16n nfin=2 w=58n multi=1 nf=8 \
        sd=74n sa=90n sb=90n ploda1=16n ploda2=0 ploda3=0 plodb1=16n \
        plodb2=0 plodb3=0 nf_flag=1 smbt=1M smbb=1M dinsaflag=0 ppitch=0 \
        spot=103n spob=103n spotl1=103n spobl1=103n spotl2=103n \
        spobl2=103n spotr1=103n spobr1=103n spotr2=103n spobr2=103n
U297 (VDLY CODE297 VDLY VSS) nch_svt_mac l=16n nfin=2 w=58n multi=1 nf=8 \
        sd=74n sa=90n sb=90n ploda1=16n ploda2=0 ploda3=0 plodb1=16n \
        plodb2=0 plodb3=0 nf_flag=1 smbt=1M smbb=1M dinsaflag=0 ppitch=0 \
        spot=103n spob=103n spotl1=103n spobl1=103n spotl2=103n \
        spobl2=103n spotr1=103n spobr1=103n spotr2=103n spobr2=103n
U296 (VDLY CODE296 VDLY VSS) nch_svt_mac l=16n nfin=2 w=58n multi=1 nf=8 \
        sd=74n sa=90n sb=90n ploda1=16n ploda2=0 ploda3=0 plodb1=16n \
        plodb2=0 plodb3=0 nf_flag=1 smbt=1M smbb=1M dinsaflag=0 ppitch=0 \
        spot=103n spob=103n spotl1=103n spobl1=103n spotl2=103n \
        spobl2=103n spotr1=103n spobr1=103n spotr2=103n spobr2=103n
U295 (VDLY CODE295 VDLY VSS) nch_svt_mac l=16n nfin=2 w=58n multi=1 nf=8 \
        sd=74n sa=90n sb=90n ploda1=16n ploda2=0 ploda3=0 plodb1=16n \
        plodb2=0 plodb3=0 nf_flag=1 smbt=1M smbb=1M dinsaflag=0 ppitch=0 \
        spot=103n spob=103n spotl1=103n spobl1=103n spotl2=103n \
        spobl2=103n spotr1=103n spobr1=103n spotr2=103n spobr2=103n
U294 (VDLY CODE294 VDLY VSS) nch_svt_mac l=16n nfin=2 w=58n multi=1 nf=8 \
        sd=74n sa=90n sb=90n ploda1=16n ploda2=0 ploda3=0 plodb1=16n \
        plodb2=0 plodb3=0 nf_flag=1 smbt=1M smbb=1M dinsaflag=0 ppitch=0 \
        spot=103n spob=103n spotl1=103n spobl1=103n spotl2=103n \
        spobl2=103n spotr1=103n spobr1=103n spotr2=103n spobr2=103n
U293 (VDLY CODE293 VDLY VSS) nch_svt_mac l=16n nfin=2 w=58n multi=1 nf=8 \
        sd=74n sa=90n sb=90n ploda1=16n ploda2=0 ploda3=0 plodb1=16n \
        plodb2=0 plodb3=0 nf_flag=1 smbt=1M smbb=1M dinsaflag=0 ppitch=0 \
        spot=103n spob=103n spotl1=103n spobl1=103n spotl2=103n \
        spobl2=103n spotr1=103n spobr1=103n spotr2=103n spobr2=103n
U292 (VDLY CODE292 VDLY VSS) nch_svt_mac l=16n nfin=2 w=58n multi=1 nf=8 \
        sd=74n sa=90n sb=90n ploda1=16n ploda2=0 ploda3=0 plodb1=16n \
        plodb2=0 plodb3=0 nf_flag=1 smbt=1M smbb=1M dinsaflag=0 ppitch=0 \
        spot=103n spob=103n spotl1=103n spobl1=103n spotl2=103n \
        spobl2=103n spotr1=103n spobr1=103n spotr2=103n spobr2=103n
U291 (VDLY CODE291 VDLY VSS) nch_svt_mac l=16n nfin=2 w=58n multi=1 nf=8 \
        sd=74n sa=90n sb=90n ploda1=16n ploda2=0 ploda3=0 plodb1=16n \
        plodb2=0 plodb3=0 nf_flag=1 smbt=1M smbb=1M dinsaflag=0 ppitch=0 \
        spot=103n spob=103n spotl1=103n spobl1=103n spotl2=103n \
        spobl2=103n spotr1=103n spobr1=103n spotr2=103n spobr2=103n
U290 (VDLY CODE290 VDLY VSS) nch_svt_mac l=16n nfin=2 w=58n multi=1 nf=8 \
        sd=74n sa=90n sb=90n ploda1=16n ploda2=0 ploda3=0 plodb1=16n \
        plodb2=0 plodb3=0 nf_flag=1 smbt=1M smbb=1M dinsaflag=0 ppitch=0 \
        spot=103n spob=103n spotl1=103n spobl1=103n spotl2=103n \
        spobl2=103n spotr1=103n spobr1=103n spotr2=103n spobr2=103n
U289 (VDLY CODE289 VDLY VSS) nch_svt_mac l=16n nfin=2 w=58n multi=1 nf=8 \
        sd=74n sa=90n sb=90n ploda1=16n ploda2=0 ploda3=0 plodb1=16n \
        plodb2=0 plodb3=0 nf_flag=1 smbt=1M smbb=1M dinsaflag=0 ppitch=0 \
        spot=103n spob=103n spotl1=103n spobl1=103n spotl2=103n \
        spobl2=103n spotr1=103n spobr1=103n spotr2=103n spobr2=103n
U288 (VDLY CODE288 VDLY VSS) nch_svt_mac l=16n nfin=2 w=58n multi=1 nf=8 \
        sd=74n sa=90n sb=90n ploda1=16n ploda2=0 ploda3=0 plodb1=16n \
        plodb2=0 plodb3=0 nf_flag=1 smbt=1M smbb=1M dinsaflag=0 ppitch=0 \
        spot=103n spob=103n spotl1=103n spobl1=103n spotl2=103n \
        spobl2=103n spotr1=103n spobr1=103n spotr2=103n spobr2=103n
U287 (VDLY CODE287 VDLY VSS) nch_svt_mac l=16n nfin=2 w=58n multi=1 nf=8 \
        sd=74n sa=90n sb=90n ploda1=16n ploda2=0 ploda3=0 plodb1=16n \
        plodb2=0 plodb3=0 nf_flag=1 smbt=1M smbb=1M dinsaflag=0 ppitch=0 \
        spot=103n spob=103n spotl1=103n spobl1=103n spotl2=103n \
        spobl2=103n spotr1=103n spobr1=103n spotr2=103n spobr2=103n
U286 (VDLY CODE286 VDLY VSS) nch_svt_mac l=16n nfin=2 w=58n multi=1 nf=8 \
        sd=74n sa=90n sb=90n ploda1=16n ploda2=0 ploda3=0 plodb1=16n \
        plodb2=0 plodb3=0 nf_flag=1 smbt=1M smbb=1M dinsaflag=0 ppitch=0 \
        spot=103n spob=103n spotl1=103n spobl1=103n spotl2=103n \
        spobl2=103n spotr1=103n spobr1=103n spotr2=103n spobr2=103n
U285 (VDLY CODE285 VDLY VSS) nch_svt_mac l=16n nfin=2 w=58n multi=1 nf=8 \
        sd=74n sa=90n sb=90n ploda1=16n ploda2=0 ploda3=0 plodb1=16n \
        plodb2=0 plodb3=0 nf_flag=1 smbt=1M smbb=1M dinsaflag=0 ppitch=0 \
        spot=103n spob=103n spotl1=103n spobl1=103n spotl2=103n \
        spobl2=103n spotr1=103n spobr1=103n spotr2=103n spobr2=103n
U284 (VDLY CODE284 VDLY VSS) nch_svt_mac l=16n nfin=2 w=58n multi=1 nf=8 \
        sd=74n sa=90n sb=90n ploda1=16n ploda2=0 ploda3=0 plodb1=16n \
        plodb2=0 plodb3=0 nf_flag=1 smbt=1M smbb=1M dinsaflag=0 ppitch=0 \
        spot=103n spob=103n spotl1=103n spobl1=103n spotl2=103n \
        spobl2=103n spotr1=103n spobr1=103n spotr2=103n spobr2=103n
U283 (VDLY CODE283 VDLY VSS) nch_svt_mac l=16n nfin=2 w=58n multi=1 nf=8 \
        sd=74n sa=90n sb=90n ploda1=16n ploda2=0 ploda3=0 plodb1=16n \
        plodb2=0 plodb3=0 nf_flag=1 smbt=1M smbb=1M dinsaflag=0 ppitch=0 \
        spot=103n spob=103n spotl1=103n spobl1=103n spotl2=103n \
        spobl2=103n spotr1=103n spobr1=103n spotr2=103n spobr2=103n
U282 (VDLY CODE282 VDLY VSS) nch_svt_mac l=16n nfin=2 w=58n multi=1 nf=8 \
        sd=74n sa=90n sb=90n ploda1=16n ploda2=0 ploda3=0 plodb1=16n \
        plodb2=0 plodb3=0 nf_flag=1 smbt=1M smbb=1M dinsaflag=0 ppitch=0 \
        spot=103n spob=103n spotl1=103n spobl1=103n spotl2=103n \
        spobl2=103n spotr1=103n spobr1=103n spotr2=103n spobr2=103n
U281 (VDLY CODE281 VDLY VSS) nch_svt_mac l=16n nfin=2 w=58n multi=1 nf=8 \
        sd=74n sa=90n sb=90n ploda1=16n ploda2=0 ploda3=0 plodb1=16n \
        plodb2=0 plodb3=0 nf_flag=1 smbt=1M smbb=1M dinsaflag=0 ppitch=0 \
        spot=103n spob=103n spotl1=103n spobl1=103n spotl2=103n \
        spobl2=103n spotr1=103n spobr1=103n spotr2=103n spobr2=103n
U280 (VDLY CODE280 VDLY VSS) nch_svt_mac l=16n nfin=2 w=58n multi=1 nf=8 \
        sd=74n sa=90n sb=90n ploda1=16n ploda2=0 ploda3=0 plodb1=16n \
        plodb2=0 plodb3=0 nf_flag=1 smbt=1M smbb=1M dinsaflag=0 ppitch=0 \
        spot=103n spob=103n spotl1=103n spobl1=103n spotl2=103n \
        spobl2=103n spotr1=103n spobr1=103n spotr2=103n spobr2=103n
U279 (VDLY CODE279 VDLY VSS) nch_svt_mac l=16n nfin=2 w=58n multi=1 nf=8 \
        sd=74n sa=90n sb=90n ploda1=16n ploda2=0 ploda3=0 plodb1=16n \
        plodb2=0 plodb3=0 nf_flag=1 smbt=1M smbb=1M dinsaflag=0 ppitch=0 \
        spot=103n spob=103n spotl1=103n spobl1=103n spotl2=103n \
        spobl2=103n spotr1=103n spobr1=103n spotr2=103n spobr2=103n
U278 (VDLY CODE278 VDLY VSS) nch_svt_mac l=16n nfin=2 w=58n multi=1 nf=8 \
        sd=74n sa=90n sb=90n ploda1=16n ploda2=0 ploda3=0 plodb1=16n \
        plodb2=0 plodb3=0 nf_flag=1 smbt=1M smbb=1M dinsaflag=0 ppitch=0 \
        spot=103n spob=103n spotl1=103n spobl1=103n spotl2=103n \
        spobl2=103n spotr1=103n spobr1=103n spotr2=103n spobr2=103n
U277 (VDLY CODE277 VDLY VSS) nch_svt_mac l=16n nfin=2 w=58n multi=1 nf=8 \
        sd=74n sa=90n sb=90n ploda1=16n ploda2=0 ploda3=0 plodb1=16n \
        plodb2=0 plodb3=0 nf_flag=1 smbt=1M smbb=1M dinsaflag=0 ppitch=0 \
        spot=103n spob=103n spotl1=103n spobl1=103n spotl2=103n \
        spobl2=103n spotr1=103n spobr1=103n spotr2=103n spobr2=103n
U276 (VDLY CODE276 VDLY VSS) nch_svt_mac l=16n nfin=2 w=58n multi=1 nf=8 \
        sd=74n sa=90n sb=90n ploda1=16n ploda2=0 ploda3=0 plodb1=16n \
        plodb2=0 plodb3=0 nf_flag=1 smbt=1M smbb=1M dinsaflag=0 ppitch=0 \
        spot=103n spob=103n spotl1=103n spobl1=103n spotl2=103n \
        spobl2=103n spotr1=103n spobr1=103n spotr2=103n spobr2=103n
U275 (VDLY CODE275 VDLY VSS) nch_svt_mac l=16n nfin=2 w=58n multi=1 nf=8 \
        sd=74n sa=90n sb=90n ploda1=16n ploda2=0 ploda3=0 plodb1=16n \
        plodb2=0 plodb3=0 nf_flag=1 smbt=1M smbb=1M dinsaflag=0 ppitch=0 \
        spot=103n spob=103n spotl1=103n spobl1=103n spotl2=103n \
        spobl2=103n spotr1=103n spobr1=103n spotr2=103n spobr2=103n
U274 (VDLY CODE274 VDLY VSS) nch_svt_mac l=16n nfin=2 w=58n multi=1 nf=8 \
        sd=74n sa=90n sb=90n ploda1=16n ploda2=0 ploda3=0 plodb1=16n \
        plodb2=0 plodb3=0 nf_flag=1 smbt=1M smbb=1M dinsaflag=0 ppitch=0 \
        spot=103n spob=103n spotl1=103n spobl1=103n spotl2=103n \
        spobl2=103n spotr1=103n spobr1=103n spotr2=103n spobr2=103n
U273 (VDLY CODE273 VDLY VSS) nch_svt_mac l=16n nfin=2 w=58n multi=1 nf=8 \
        sd=74n sa=90n sb=90n ploda1=16n ploda2=0 ploda3=0 plodb1=16n \
        plodb2=0 plodb3=0 nf_flag=1 smbt=1M smbb=1M dinsaflag=0 ppitch=0 \
        spot=103n spob=103n spotl1=103n spobl1=103n spotl2=103n \
        spobl2=103n spotr1=103n spobr1=103n spotr2=103n spobr2=103n
U272 (VDLY CODE272 VDLY VSS) nch_svt_mac l=16n nfin=2 w=58n multi=1 nf=8 \
        sd=74n sa=90n sb=90n ploda1=16n ploda2=0 ploda3=0 plodb1=16n \
        plodb2=0 plodb3=0 nf_flag=1 smbt=1M smbb=1M dinsaflag=0 ppitch=0 \
        spot=103n spob=103n spotl1=103n spobl1=103n spotl2=103n \
        spobl2=103n spotr1=103n spobr1=103n spotr2=103n spobr2=103n
U271 (VDLY CODE271 VDLY VSS) nch_svt_mac l=16n nfin=2 w=58n multi=1 nf=8 \
        sd=74n sa=90n sb=90n ploda1=16n ploda2=0 ploda3=0 plodb1=16n \
        plodb2=0 plodb3=0 nf_flag=1 smbt=1M smbb=1M dinsaflag=0 ppitch=0 \
        spot=103n spob=103n spotl1=103n spobl1=103n spotl2=103n \
        spobl2=103n spotr1=103n spobr1=103n spotr2=103n spobr2=103n
U270 (VDLY CODE270 VDLY VSS) nch_svt_mac l=16n nfin=2 w=58n multi=1 nf=8 \
        sd=74n sa=90n sb=90n ploda1=16n ploda2=0 ploda3=0 plodb1=16n \
        plodb2=0 plodb3=0 nf_flag=1 smbt=1M smbb=1M dinsaflag=0 ppitch=0 \
        spot=103n spob=103n spotl1=103n spobl1=103n spotl2=103n \
        spobl2=103n spotr1=103n spobr1=103n spotr2=103n spobr2=103n
U269 (VDLY CODE269 VDLY VSS) nch_svt_mac l=16n nfin=2 w=58n multi=1 nf=8 \
        sd=74n sa=90n sb=90n ploda1=16n ploda2=0 ploda3=0 plodb1=16n \
        plodb2=0 plodb3=0 nf_flag=1 smbt=1M smbb=1M dinsaflag=0 ppitch=0 \
        spot=103n spob=103n spotl1=103n spobl1=103n spotl2=103n \
        spobl2=103n spotr1=103n spobr1=103n spotr2=103n spobr2=103n
U268 (VDLY CODE268 VDLY VSS) nch_svt_mac l=16n nfin=2 w=58n multi=1 nf=8 \
        sd=74n sa=90n sb=90n ploda1=16n ploda2=0 ploda3=0 plodb1=16n \
        plodb2=0 plodb3=0 nf_flag=1 smbt=1M smbb=1M dinsaflag=0 ppitch=0 \
        spot=103n spob=103n spotl1=103n spobl1=103n spotl2=103n \
        spobl2=103n spotr1=103n spobr1=103n spotr2=103n spobr2=103n
U267 (VDLY CODE267 VDLY VSS) nch_svt_mac l=16n nfin=2 w=58n multi=1 nf=8 \
        sd=74n sa=90n sb=90n ploda1=16n ploda2=0 ploda3=0 plodb1=16n \
        plodb2=0 plodb3=0 nf_flag=1 smbt=1M smbb=1M dinsaflag=0 ppitch=0 \
        spot=103n spob=103n spotl1=103n spobl1=103n spotl2=103n \
        spobl2=103n spotr1=103n spobr1=103n spotr2=103n spobr2=103n
U266 (VDLY CODE266 VDLY VSS) nch_svt_mac l=16n nfin=2 w=58n multi=1 nf=8 \
        sd=74n sa=90n sb=90n ploda1=16n ploda2=0 ploda3=0 plodb1=16n \
        plodb2=0 plodb3=0 nf_flag=1 smbt=1M smbb=1M dinsaflag=0 ppitch=0 \
        spot=103n spob=103n spotl1=103n spobl1=103n spotl2=103n \
        spobl2=103n spotr1=103n spobr1=103n spotr2=103n spobr2=103n
U265 (VDLY CODE265 VDLY VSS) nch_svt_mac l=16n nfin=2 w=58n multi=1 nf=8 \
        sd=74n sa=90n sb=90n ploda1=16n ploda2=0 ploda3=0 plodb1=16n \
        plodb2=0 plodb3=0 nf_flag=1 smbt=1M smbb=1M dinsaflag=0 ppitch=0 \
        spot=103n spob=103n spotl1=103n spobl1=103n spotl2=103n \
        spobl2=103n spotr1=103n spobr1=103n spotr2=103n spobr2=103n
U264 (VDLY CODE264 VDLY VSS) nch_svt_mac l=16n nfin=2 w=58n multi=1 nf=8 \
        sd=74n sa=90n sb=90n ploda1=16n ploda2=0 ploda3=0 plodb1=16n \
        plodb2=0 plodb3=0 nf_flag=1 smbt=1M smbb=1M dinsaflag=0 ppitch=0 \
        spot=103n spob=103n spotl1=103n spobl1=103n spotl2=103n \
        spobl2=103n spotr1=103n spobr1=103n spotr2=103n spobr2=103n
U263 (VDLY CODE263 VDLY VSS) nch_svt_mac l=16n nfin=2 w=58n multi=1 nf=8 \
        sd=74n sa=90n sb=90n ploda1=16n ploda2=0 ploda3=0 plodb1=16n \
        plodb2=0 plodb3=0 nf_flag=1 smbt=1M smbb=1M dinsaflag=0 ppitch=0 \
        spot=103n spob=103n spotl1=103n spobl1=103n spotl2=103n \
        spobl2=103n spotr1=103n spobr1=103n spotr2=103n spobr2=103n
U262 (VDLY CODE262 VDLY VSS) nch_svt_mac l=16n nfin=2 w=58n multi=1 nf=8 \
        sd=74n sa=90n sb=90n ploda1=16n ploda2=0 ploda3=0 plodb1=16n \
        plodb2=0 plodb3=0 nf_flag=1 smbt=1M smbb=1M dinsaflag=0 ppitch=0 \
        spot=103n spob=103n spotl1=103n spobl1=103n spotl2=103n \
        spobl2=103n spotr1=103n spobr1=103n spotr2=103n spobr2=103n
U261 (VDLY CODE261 VDLY VSS) nch_svt_mac l=16n nfin=2 w=58n multi=1 nf=8 \
        sd=74n sa=90n sb=90n ploda1=16n ploda2=0 ploda3=0 plodb1=16n \
        plodb2=0 plodb3=0 nf_flag=1 smbt=1M smbb=1M dinsaflag=0 ppitch=0 \
        spot=103n spob=103n spotl1=103n spobl1=103n spotl2=103n \
        spobl2=103n spotr1=103n spobr1=103n spotr2=103n spobr2=103n
U260 (VDLY CODE260 VDLY VSS) nch_svt_mac l=16n nfin=2 w=58n multi=1 nf=8 \
        sd=74n sa=90n sb=90n ploda1=16n ploda2=0 ploda3=0 plodb1=16n \
        plodb2=0 plodb3=0 nf_flag=1 smbt=1M smbb=1M dinsaflag=0 ppitch=0 \
        spot=103n spob=103n spotl1=103n spobl1=103n spotl2=103n \
        spobl2=103n spotr1=103n spobr1=103n spotr2=103n spobr2=103n
U259 (VDLY CODE259 VDLY VSS) nch_svt_mac l=16n nfin=2 w=58n multi=1 nf=8 \
        sd=74n sa=90n sb=90n ploda1=16n ploda2=0 ploda3=0 plodb1=16n \
        plodb2=0 plodb3=0 nf_flag=1 smbt=1M smbb=1M dinsaflag=0 ppitch=0 \
        spot=103n spob=103n spotl1=103n spobl1=103n spotl2=103n \
        spobl2=103n spotr1=103n spobr1=103n spotr2=103n spobr2=103n
U258 (VDLY CODE258 VDLY VSS) nch_svt_mac l=16n nfin=2 w=58n multi=1 nf=8 \
        sd=74n sa=90n sb=90n ploda1=16n ploda2=0 ploda3=0 plodb1=16n \
        plodb2=0 plodb3=0 nf_flag=1 smbt=1M smbb=1M dinsaflag=0 ppitch=0 \
        spot=103n spob=103n spotl1=103n spobl1=103n spotl2=103n \
        spobl2=103n spotr1=103n spobr1=103n spotr2=103n spobr2=103n
U257 (VDLY CODE257 VDLY VSS) nch_svt_mac l=16n nfin=2 w=58n multi=1 nf=8 \
        sd=74n sa=90n sb=90n ploda1=16n ploda2=0 ploda3=0 plodb1=16n \
        plodb2=0 plodb3=0 nf_flag=1 smbt=1M smbb=1M dinsaflag=0 ppitch=0 \
        spot=103n spob=103n spotl1=103n spobl1=103n spotl2=103n \
        spobl2=103n spotr1=103n spobr1=103n spotr2=103n spobr2=103n
U256 (VDLY CODE256 VDLY VSS) nch_svt_mac l=16n nfin=2 w=58n multi=1 nf=8 \
        sd=74n sa=90n sb=90n ploda1=16n ploda2=0 ploda3=0 plodb1=16n \
        plodb2=0 plodb3=0 nf_flag=1 smbt=1M smbb=1M dinsaflag=0 ppitch=0 \
        spot=103n spob=103n spotl1=103n spobl1=103n spotl2=103n \
        spobl2=103n spotr1=103n spobr1=103n spotr2=103n spobr2=103n
U255 (VDLY CODE255 VDLY VSS) nch_svt_mac l=16n nfin=2 w=58n multi=1 nf=8 \
        sd=74n sa=90n sb=90n ploda1=16n ploda2=0 ploda3=0 plodb1=16n \
        plodb2=0 plodb3=0 nf_flag=1 smbt=1M smbb=1M dinsaflag=0 ppitch=0 \
        spot=103n spob=103n spotl1=103n spobl1=103n spotl2=103n \
        spobl2=103n spotr1=103n spobr1=103n spotr2=103n spobr2=103n
U254 (VDLY CODE254 VDLY VSS) nch_svt_mac l=16n nfin=2 w=58n multi=1 nf=8 \
        sd=74n sa=90n sb=90n ploda1=16n ploda2=0 ploda3=0 plodb1=16n \
        plodb2=0 plodb3=0 nf_flag=1 smbt=1M smbb=1M dinsaflag=0 ppitch=0 \
        spot=103n spob=103n spotl1=103n spobl1=103n spotl2=103n \
        spobl2=103n spotr1=103n spobr1=103n spotr2=103n spobr2=103n
U253 (VDLY CODE253 VDLY VSS) nch_svt_mac l=16n nfin=2 w=58n multi=1 nf=8 \
        sd=74n sa=90n sb=90n ploda1=16n ploda2=0 ploda3=0 plodb1=16n \
        plodb2=0 plodb3=0 nf_flag=1 smbt=1M smbb=1M dinsaflag=0 ppitch=0 \
        spot=103n spob=103n spotl1=103n spobl1=103n spotl2=103n \
        spobl2=103n spotr1=103n spobr1=103n spotr2=103n spobr2=103n
U252 (VDLY CODE252 VDLY VSS) nch_svt_mac l=16n nfin=2 w=58n multi=1 nf=8 \
        sd=74n sa=90n sb=90n ploda1=16n ploda2=0 ploda3=0 plodb1=16n \
        plodb2=0 plodb3=0 nf_flag=1 smbt=1M smbb=1M dinsaflag=0 ppitch=0 \
        spot=103n spob=103n spotl1=103n spobl1=103n spotl2=103n \
        spobl2=103n spotr1=103n spobr1=103n spotr2=103n spobr2=103n
U251 (VDLY CODE251 VDLY VSS) nch_svt_mac l=16n nfin=2 w=58n multi=1 nf=8 \
        sd=74n sa=90n sb=90n ploda1=16n ploda2=0 ploda3=0 plodb1=16n \
        plodb2=0 plodb3=0 nf_flag=1 smbt=1M smbb=1M dinsaflag=0 ppitch=0 \
        spot=103n spob=103n spotl1=103n spobl1=103n spotl2=103n \
        spobl2=103n spotr1=103n spobr1=103n spotr2=103n spobr2=103n
U250 (VDLY CODE250 VDLY VSS) nch_svt_mac l=16n nfin=2 w=58n multi=1 nf=8 \
        sd=74n sa=90n sb=90n ploda1=16n ploda2=0 ploda3=0 plodb1=16n \
        plodb2=0 plodb3=0 nf_flag=1 smbt=1M smbb=1M dinsaflag=0 ppitch=0 \
        spot=103n spob=103n spotl1=103n spobl1=103n spotl2=103n \
        spobl2=103n spotr1=103n spobr1=103n spotr2=103n spobr2=103n
U249 (VDLY CODE249 VDLY VSS) nch_svt_mac l=16n nfin=2 w=58n multi=1 nf=8 \
        sd=74n sa=90n sb=90n ploda1=16n ploda2=0 ploda3=0 plodb1=16n \
        plodb2=0 plodb3=0 nf_flag=1 smbt=1M smbb=1M dinsaflag=0 ppitch=0 \
        spot=103n spob=103n spotl1=103n spobl1=103n spotl2=103n \
        spobl2=103n spotr1=103n spobr1=103n spotr2=103n spobr2=103n
U248 (VDLY CODE248 VDLY VSS) nch_svt_mac l=16n nfin=2 w=58n multi=1 nf=8 \
        sd=74n sa=90n sb=90n ploda1=16n ploda2=0 ploda3=0 plodb1=16n \
        plodb2=0 plodb3=0 nf_flag=1 smbt=1M smbb=1M dinsaflag=0 ppitch=0 \
        spot=103n spob=103n spotl1=103n spobl1=103n spotl2=103n \
        spobl2=103n spotr1=103n spobr1=103n spotr2=103n spobr2=103n
U247 (VDLY CODE247 VDLY VSS) nch_svt_mac l=16n nfin=2 w=58n multi=1 nf=8 \
        sd=74n sa=90n sb=90n ploda1=16n ploda2=0 ploda3=0 plodb1=16n \
        plodb2=0 plodb3=0 nf_flag=1 smbt=1M smbb=1M dinsaflag=0 ppitch=0 \
        spot=103n spob=103n spotl1=103n spobl1=103n spotl2=103n \
        spobl2=103n spotr1=103n spobr1=103n spotr2=103n spobr2=103n
U246 (VDLY CODE246 VDLY VSS) nch_svt_mac l=16n nfin=2 w=58n multi=1 nf=8 \
        sd=74n sa=90n sb=90n ploda1=16n ploda2=0 ploda3=0 plodb1=16n \
        plodb2=0 plodb3=0 nf_flag=1 smbt=1M smbb=1M dinsaflag=0 ppitch=0 \
        spot=103n spob=103n spotl1=103n spobl1=103n spotl2=103n \
        spobl2=103n spotr1=103n spobr1=103n spotr2=103n spobr2=103n
U245 (VDLY CODE245 VDLY VSS) nch_svt_mac l=16n nfin=2 w=58n multi=1 nf=8 \
        sd=74n sa=90n sb=90n ploda1=16n ploda2=0 ploda3=0 plodb1=16n \
        plodb2=0 plodb3=0 nf_flag=1 smbt=1M smbb=1M dinsaflag=0 ppitch=0 \
        spot=103n spob=103n spotl1=103n spobl1=103n spotl2=103n \
        spobl2=103n spotr1=103n spobr1=103n spotr2=103n spobr2=103n
U244 (VDLY CODE244 VDLY VSS) nch_svt_mac l=16n nfin=2 w=58n multi=1 nf=8 \
        sd=74n sa=90n sb=90n ploda1=16n ploda2=0 ploda3=0 plodb1=16n \
        plodb2=0 plodb3=0 nf_flag=1 smbt=1M smbb=1M dinsaflag=0 ppitch=0 \
        spot=103n spob=103n spotl1=103n spobl1=103n spotl2=103n \
        spobl2=103n spotr1=103n spobr1=103n spotr2=103n spobr2=103n
U243 (VDLY CODE243 VDLY VSS) nch_svt_mac l=16n nfin=2 w=58n multi=1 nf=8 \
        sd=74n sa=90n sb=90n ploda1=16n ploda2=0 ploda3=0 plodb1=16n \
        plodb2=0 plodb3=0 nf_flag=1 smbt=1M smbb=1M dinsaflag=0 ppitch=0 \
        spot=103n spob=103n spotl1=103n spobl1=103n spotl2=103n \
        spobl2=103n spotr1=103n spobr1=103n spotr2=103n spobr2=103n
U242 (VDLY CODE242 VDLY VSS) nch_svt_mac l=16n nfin=2 w=58n multi=1 nf=8 \
        sd=74n sa=90n sb=90n ploda1=16n ploda2=0 ploda3=0 plodb1=16n \
        plodb2=0 plodb3=0 nf_flag=1 smbt=1M smbb=1M dinsaflag=0 ppitch=0 \
        spot=103n spob=103n spotl1=103n spobl1=103n spotl2=103n \
        spobl2=103n spotr1=103n spobr1=103n spotr2=103n spobr2=103n
U241 (VDLY CODE241 VDLY VSS) nch_svt_mac l=16n nfin=2 w=58n multi=1 nf=8 \
        sd=74n sa=90n sb=90n ploda1=16n ploda2=0 ploda3=0 plodb1=16n \
        plodb2=0 plodb3=0 nf_flag=1 smbt=1M smbb=1M dinsaflag=0 ppitch=0 \
        spot=103n spob=103n spotl1=103n spobl1=103n spotl2=103n \
        spobl2=103n spotr1=103n spobr1=103n spotr2=103n spobr2=103n
U240 (VDLY CODE240 VDLY VSS) nch_svt_mac l=16n nfin=2 w=58n multi=1 nf=8 \
        sd=74n sa=90n sb=90n ploda1=16n ploda2=0 ploda3=0 plodb1=16n \
        plodb2=0 plodb3=0 nf_flag=1 smbt=1M smbb=1M dinsaflag=0 ppitch=0 \
        spot=103n spob=103n spotl1=103n spobl1=103n spotl2=103n \
        spobl2=103n spotr1=103n spobr1=103n spotr2=103n spobr2=103n
U239 (VDLY CODE239 VDLY VSS) nch_svt_mac l=16n nfin=2 w=58n multi=1 nf=8 \
        sd=74n sa=90n sb=90n ploda1=16n ploda2=0 ploda3=0 plodb1=16n \
        plodb2=0 plodb3=0 nf_flag=1 smbt=1M smbb=1M dinsaflag=0 ppitch=0 \
        spot=103n spob=103n spotl1=103n spobl1=103n spotl2=103n \
        spobl2=103n spotr1=103n spobr1=103n spotr2=103n spobr2=103n
U238 (VDLY CODE238 VDLY VSS) nch_svt_mac l=16n nfin=2 w=58n multi=1 nf=8 \
        sd=74n sa=90n sb=90n ploda1=16n ploda2=0 ploda3=0 plodb1=16n \
        plodb2=0 plodb3=0 nf_flag=1 smbt=1M smbb=1M dinsaflag=0 ppitch=0 \
        spot=103n spob=103n spotl1=103n spobl1=103n spotl2=103n \
        spobl2=103n spotr1=103n spobr1=103n spotr2=103n spobr2=103n
U237 (VDLY CODE237 VDLY VSS) nch_svt_mac l=16n nfin=2 w=58n multi=1 nf=8 \
        sd=74n sa=90n sb=90n ploda1=16n ploda2=0 ploda3=0 plodb1=16n \
        plodb2=0 plodb3=0 nf_flag=1 smbt=1M smbb=1M dinsaflag=0 ppitch=0 \
        spot=103n spob=103n spotl1=103n spobl1=103n spotl2=103n \
        spobl2=103n spotr1=103n spobr1=103n spotr2=103n spobr2=103n
U236 (VDLY CODE236 VDLY VSS) nch_svt_mac l=16n nfin=2 w=58n multi=1 nf=8 \
        sd=74n sa=90n sb=90n ploda1=16n ploda2=0 ploda3=0 plodb1=16n \
        plodb2=0 plodb3=0 nf_flag=1 smbt=1M smbb=1M dinsaflag=0 ppitch=0 \
        spot=103n spob=103n spotl1=103n spobl1=103n spotl2=103n \
        spobl2=103n spotr1=103n spobr1=103n spotr2=103n spobr2=103n
U235 (VDLY CODE235 VDLY VSS) nch_svt_mac l=16n nfin=2 w=58n multi=1 nf=8 \
        sd=74n sa=90n sb=90n ploda1=16n ploda2=0 ploda3=0 plodb1=16n \
        plodb2=0 plodb3=0 nf_flag=1 smbt=1M smbb=1M dinsaflag=0 ppitch=0 \
        spot=103n spob=103n spotl1=103n spobl1=103n spotl2=103n \
        spobl2=103n spotr1=103n spobr1=103n spotr2=103n spobr2=103n
U234 (VDLY CODE234 VDLY VSS) nch_svt_mac l=16n nfin=2 w=58n multi=1 nf=8 \
        sd=74n sa=90n sb=90n ploda1=16n ploda2=0 ploda3=0 plodb1=16n \
        plodb2=0 plodb3=0 nf_flag=1 smbt=1M smbb=1M dinsaflag=0 ppitch=0 \
        spot=103n spob=103n spotl1=103n spobl1=103n spotl2=103n \
        spobl2=103n spotr1=103n spobr1=103n spotr2=103n spobr2=103n
U233 (VDLY CODE233 VDLY VSS) nch_svt_mac l=16n nfin=2 w=58n multi=1 nf=8 \
        sd=74n sa=90n sb=90n ploda1=16n ploda2=0 ploda3=0 plodb1=16n \
        plodb2=0 plodb3=0 nf_flag=1 smbt=1M smbb=1M dinsaflag=0 ppitch=0 \
        spot=103n spob=103n spotl1=103n spobl1=103n spotl2=103n \
        spobl2=103n spotr1=103n spobr1=103n spotr2=103n spobr2=103n
U232 (VDLY CODE232 VDLY VSS) nch_svt_mac l=16n nfin=2 w=58n multi=1 nf=8 \
        sd=74n sa=90n sb=90n ploda1=16n ploda2=0 ploda3=0 plodb1=16n \
        plodb2=0 plodb3=0 nf_flag=1 smbt=1M smbb=1M dinsaflag=0 ppitch=0 \
        spot=103n spob=103n spotl1=103n spobl1=103n spotl2=103n \
        spobl2=103n spotr1=103n spobr1=103n spotr2=103n spobr2=103n
U231 (VDLY CODE231 VDLY VSS) nch_svt_mac l=16n nfin=2 w=58n multi=1 nf=8 \
        sd=74n sa=90n sb=90n ploda1=16n ploda2=0 ploda3=0 plodb1=16n \
        plodb2=0 plodb3=0 nf_flag=1 smbt=1M smbb=1M dinsaflag=0 ppitch=0 \
        spot=103n spob=103n spotl1=103n spobl1=103n spotl2=103n \
        spobl2=103n spotr1=103n spobr1=103n spotr2=103n spobr2=103n
U230 (VDLY CODE230 VDLY VSS) nch_svt_mac l=16n nfin=2 w=58n multi=1 nf=8 \
        sd=74n sa=90n sb=90n ploda1=16n ploda2=0 ploda3=0 plodb1=16n \
        plodb2=0 plodb3=0 nf_flag=1 smbt=1M smbb=1M dinsaflag=0 ppitch=0 \
        spot=103n spob=103n spotl1=103n spobl1=103n spotl2=103n \
        spobl2=103n spotr1=103n spobr1=103n spotr2=103n spobr2=103n
U229 (VDLY CODE229 VDLY VSS) nch_svt_mac l=16n nfin=2 w=58n multi=1 nf=8 \
        sd=74n sa=90n sb=90n ploda1=16n ploda2=0 ploda3=0 plodb1=16n \
        plodb2=0 plodb3=0 nf_flag=1 smbt=1M smbb=1M dinsaflag=0 ppitch=0 \
        spot=103n spob=103n spotl1=103n spobl1=103n spotl2=103n \
        spobl2=103n spotr1=103n spobr1=103n spotr2=103n spobr2=103n
U228 (VDLY CODE228 VDLY VSS) nch_svt_mac l=16n nfin=2 w=58n multi=1 nf=8 \
        sd=74n sa=90n sb=90n ploda1=16n ploda2=0 ploda3=0 plodb1=16n \
        plodb2=0 plodb3=0 nf_flag=1 smbt=1M smbb=1M dinsaflag=0 ppitch=0 \
        spot=103n spob=103n spotl1=103n spobl1=103n spotl2=103n \
        spobl2=103n spotr1=103n spobr1=103n spotr2=103n spobr2=103n
U227 (VDLY CODE227 VDLY VSS) nch_svt_mac l=16n nfin=2 w=58n multi=1 nf=8 \
        sd=74n sa=90n sb=90n ploda1=16n ploda2=0 ploda3=0 plodb1=16n \
        plodb2=0 plodb3=0 nf_flag=1 smbt=1M smbb=1M dinsaflag=0 ppitch=0 \
        spot=103n spob=103n spotl1=103n spobl1=103n spotl2=103n \
        spobl2=103n spotr1=103n spobr1=103n spotr2=103n spobr2=103n
U226 (VDLY CODE226 VDLY VSS) nch_svt_mac l=16n nfin=2 w=58n multi=1 nf=8 \
        sd=74n sa=90n sb=90n ploda1=16n ploda2=0 ploda3=0 plodb1=16n \
        plodb2=0 plodb3=0 nf_flag=1 smbt=1M smbb=1M dinsaflag=0 ppitch=0 \
        spot=103n spob=103n spotl1=103n spobl1=103n spotl2=103n \
        spobl2=103n spotr1=103n spobr1=103n spotr2=103n spobr2=103n
U225 (VDLY CODE225 VDLY VSS) nch_svt_mac l=16n nfin=2 w=58n multi=1 nf=8 \
        sd=74n sa=90n sb=90n ploda1=16n ploda2=0 ploda3=0 plodb1=16n \
        plodb2=0 plodb3=0 nf_flag=1 smbt=1M smbb=1M dinsaflag=0 ppitch=0 \
        spot=103n spob=103n spotl1=103n spobl1=103n spotl2=103n \
        spobl2=103n spotr1=103n spobr1=103n spotr2=103n spobr2=103n
U224 (VDLY CODE224 VDLY VSS) nch_svt_mac l=16n nfin=2 w=58n multi=1 nf=8 \
        sd=74n sa=90n sb=90n ploda1=16n ploda2=0 ploda3=0 plodb1=16n \
        plodb2=0 plodb3=0 nf_flag=1 smbt=1M smbb=1M dinsaflag=0 ppitch=0 \
        spot=103n spob=103n spotl1=103n spobl1=103n spotl2=103n \
        spobl2=103n spotr1=103n spobr1=103n spotr2=103n spobr2=103n
U223 (VDLY CODE223 VDLY VSS) nch_svt_mac l=16n nfin=2 w=58n multi=1 nf=8 \
        sd=74n sa=90n sb=90n ploda1=16n ploda2=0 ploda3=0 plodb1=16n \
        plodb2=0 plodb3=0 nf_flag=1 smbt=1M smbb=1M dinsaflag=0 ppitch=0 \
        spot=103n spob=103n spotl1=103n spobl1=103n spotl2=103n \
        spobl2=103n spotr1=103n spobr1=103n spotr2=103n spobr2=103n
U222 (VDLY CODE222 VDLY VSS) nch_svt_mac l=16n nfin=2 w=58n multi=1 nf=8 \
        sd=74n sa=90n sb=90n ploda1=16n ploda2=0 ploda3=0 plodb1=16n \
        plodb2=0 plodb3=0 nf_flag=1 smbt=1M smbb=1M dinsaflag=0 ppitch=0 \
        spot=103n spob=103n spotl1=103n spobl1=103n spotl2=103n \
        spobl2=103n spotr1=103n spobr1=103n spotr2=103n spobr2=103n
U221 (VDLY CODE221 VDLY VSS) nch_svt_mac l=16n nfin=2 w=58n multi=1 nf=8 \
        sd=74n sa=90n sb=90n ploda1=16n ploda2=0 ploda3=0 plodb1=16n \
        plodb2=0 plodb3=0 nf_flag=1 smbt=1M smbb=1M dinsaflag=0 ppitch=0 \
        spot=103n spob=103n spotl1=103n spobl1=103n spotl2=103n \
        spobl2=103n spotr1=103n spobr1=103n spotr2=103n spobr2=103n
U220 (VDLY CODE220 VDLY VSS) nch_svt_mac l=16n nfin=2 w=58n multi=1 nf=8 \
        sd=74n sa=90n sb=90n ploda1=16n ploda2=0 ploda3=0 plodb1=16n \
        plodb2=0 plodb3=0 nf_flag=1 smbt=1M smbb=1M dinsaflag=0 ppitch=0 \
        spot=103n spob=103n spotl1=103n spobl1=103n spotl2=103n \
        spobl2=103n spotr1=103n spobr1=103n spotr2=103n spobr2=103n
U219 (VDLY CODE219 VDLY VSS) nch_svt_mac l=16n nfin=2 w=58n multi=1 nf=8 \
        sd=74n sa=90n sb=90n ploda1=16n ploda2=0 ploda3=0 plodb1=16n \
        plodb2=0 plodb3=0 nf_flag=1 smbt=1M smbb=1M dinsaflag=0 ppitch=0 \
        spot=103n spob=103n spotl1=103n spobl1=103n spotl2=103n \
        spobl2=103n spotr1=103n spobr1=103n spotr2=103n spobr2=103n
U218 (VDLY CODE218 VDLY VSS) nch_svt_mac l=16n nfin=2 w=58n multi=1 nf=8 \
        sd=74n sa=90n sb=90n ploda1=16n ploda2=0 ploda3=0 plodb1=16n \
        plodb2=0 plodb3=0 nf_flag=1 smbt=1M smbb=1M dinsaflag=0 ppitch=0 \
        spot=103n spob=103n spotl1=103n spobl1=103n spotl2=103n \
        spobl2=103n spotr1=103n spobr1=103n spotr2=103n spobr2=103n
U217 (VDLY CODE217 VDLY VSS) nch_svt_mac l=16n nfin=2 w=58n multi=1 nf=8 \
        sd=74n sa=90n sb=90n ploda1=16n ploda2=0 ploda3=0 plodb1=16n \
        plodb2=0 plodb3=0 nf_flag=1 smbt=1M smbb=1M dinsaflag=0 ppitch=0 \
        spot=103n spob=103n spotl1=103n spobl1=103n spotl2=103n \
        spobl2=103n spotr1=103n spobr1=103n spotr2=103n spobr2=103n
U216 (VDLY CODE216 VDLY VSS) nch_svt_mac l=16n nfin=2 w=58n multi=1 nf=8 \
        sd=74n sa=90n sb=90n ploda1=16n ploda2=0 ploda3=0 plodb1=16n \
        plodb2=0 plodb3=0 nf_flag=1 smbt=1M smbb=1M dinsaflag=0 ppitch=0 \
        spot=103n spob=103n spotl1=103n spobl1=103n spotl2=103n \
        spobl2=103n spotr1=103n spobr1=103n spotr2=103n spobr2=103n
U215 (VDLY CODE215 VDLY VSS) nch_svt_mac l=16n nfin=2 w=58n multi=1 nf=8 \
        sd=74n sa=90n sb=90n ploda1=16n ploda2=0 ploda3=0 plodb1=16n \
        plodb2=0 plodb3=0 nf_flag=1 smbt=1M smbb=1M dinsaflag=0 ppitch=0 \
        spot=103n spob=103n spotl1=103n spobl1=103n spotl2=103n \
        spobl2=103n spotr1=103n spobr1=103n spotr2=103n spobr2=103n
U214 (VDLY CODE214 VDLY VSS) nch_svt_mac l=16n nfin=2 w=58n multi=1 nf=8 \
        sd=74n sa=90n sb=90n ploda1=16n ploda2=0 ploda3=0 plodb1=16n \
        plodb2=0 plodb3=0 nf_flag=1 smbt=1M smbb=1M dinsaflag=0 ppitch=0 \
        spot=103n spob=103n spotl1=103n spobl1=103n spotl2=103n \
        spobl2=103n spotr1=103n spobr1=103n spotr2=103n spobr2=103n
U213 (VDLY CODE213 VDLY VSS) nch_svt_mac l=16n nfin=2 w=58n multi=1 nf=8 \
        sd=74n sa=90n sb=90n ploda1=16n ploda2=0 ploda3=0 plodb1=16n \
        plodb2=0 plodb3=0 nf_flag=1 smbt=1M smbb=1M dinsaflag=0 ppitch=0 \
        spot=103n spob=103n spotl1=103n spobl1=103n spotl2=103n \
        spobl2=103n spotr1=103n spobr1=103n spotr2=103n spobr2=103n
U212 (VDLY CODE212 VDLY VSS) nch_svt_mac l=16n nfin=2 w=58n multi=1 nf=8 \
        sd=74n sa=90n sb=90n ploda1=16n ploda2=0 ploda3=0 plodb1=16n \
        plodb2=0 plodb3=0 nf_flag=1 smbt=1M smbb=1M dinsaflag=0 ppitch=0 \
        spot=103n spob=103n spotl1=103n spobl1=103n spotl2=103n \
        spobl2=103n spotr1=103n spobr1=103n spotr2=103n spobr2=103n
U211 (VDLY CODE211 VDLY VSS) nch_svt_mac l=16n nfin=2 w=58n multi=1 nf=8 \
        sd=74n sa=90n sb=90n ploda1=16n ploda2=0 ploda3=0 plodb1=16n \
        plodb2=0 plodb3=0 nf_flag=1 smbt=1M smbb=1M dinsaflag=0 ppitch=0 \
        spot=103n spob=103n spotl1=103n spobl1=103n spotl2=103n \
        spobl2=103n spotr1=103n spobr1=103n spotr2=103n spobr2=103n
U210 (VDLY CODE210 VDLY VSS) nch_svt_mac l=16n nfin=2 w=58n multi=1 nf=8 \
        sd=74n sa=90n sb=90n ploda1=16n ploda2=0 ploda3=0 plodb1=16n \
        plodb2=0 plodb3=0 nf_flag=1 smbt=1M smbb=1M dinsaflag=0 ppitch=0 \
        spot=103n spob=103n spotl1=103n spobl1=103n spotl2=103n \
        spobl2=103n spotr1=103n spobr1=103n spotr2=103n spobr2=103n
U209 (VDLY CODE209 VDLY VSS) nch_svt_mac l=16n nfin=2 w=58n multi=1 nf=8 \
        sd=74n sa=90n sb=90n ploda1=16n ploda2=0 ploda3=0 plodb1=16n \
        plodb2=0 plodb3=0 nf_flag=1 smbt=1M smbb=1M dinsaflag=0 ppitch=0 \
        spot=103n spob=103n spotl1=103n spobl1=103n spotl2=103n \
        spobl2=103n spotr1=103n spobr1=103n spotr2=103n spobr2=103n
U208 (VDLY CODE208 VDLY VSS) nch_svt_mac l=16n nfin=2 w=58n multi=1 nf=8 \
        sd=74n sa=90n sb=90n ploda1=16n ploda2=0 ploda3=0 plodb1=16n \
        plodb2=0 plodb3=0 nf_flag=1 smbt=1M smbb=1M dinsaflag=0 ppitch=0 \
        spot=103n spob=103n spotl1=103n spobl1=103n spotl2=103n \
        spobl2=103n spotr1=103n spobr1=103n spotr2=103n spobr2=103n
U207 (VDLY CODE207 VDLY VSS) nch_svt_mac l=16n nfin=2 w=58n multi=1 nf=8 \
        sd=74n sa=90n sb=90n ploda1=16n ploda2=0 ploda3=0 plodb1=16n \
        plodb2=0 plodb3=0 nf_flag=1 smbt=1M smbb=1M dinsaflag=0 ppitch=0 \
        spot=103n spob=103n spotl1=103n spobl1=103n spotl2=103n \
        spobl2=103n spotr1=103n spobr1=103n spotr2=103n spobr2=103n
U206 (VDLY CODE206 VDLY VSS) nch_svt_mac l=16n nfin=2 w=58n multi=1 nf=8 \
        sd=74n sa=90n sb=90n ploda1=16n ploda2=0 ploda3=0 plodb1=16n \
        plodb2=0 plodb3=0 nf_flag=1 smbt=1M smbb=1M dinsaflag=0 ppitch=0 \
        spot=103n spob=103n spotl1=103n spobl1=103n spotl2=103n \
        spobl2=103n spotr1=103n spobr1=103n spotr2=103n spobr2=103n
U205 (VDLY CODE205 VDLY VSS) nch_svt_mac l=16n nfin=2 w=58n multi=1 nf=8 \
        sd=74n sa=90n sb=90n ploda1=16n ploda2=0 ploda3=0 plodb1=16n \
        plodb2=0 plodb3=0 nf_flag=1 smbt=1M smbb=1M dinsaflag=0 ppitch=0 \
        spot=103n spob=103n spotl1=103n spobl1=103n spotl2=103n \
        spobl2=103n spotr1=103n spobr1=103n spotr2=103n spobr2=103n
U204 (VDLY CODE204 VDLY VSS) nch_svt_mac l=16n nfin=2 w=58n multi=1 nf=8 \
        sd=74n sa=90n sb=90n ploda1=16n ploda2=0 ploda3=0 plodb1=16n \
        plodb2=0 plodb3=0 nf_flag=1 smbt=1M smbb=1M dinsaflag=0 ppitch=0 \
        spot=103n spob=103n spotl1=103n spobl1=103n spotl2=103n \
        spobl2=103n spotr1=103n spobr1=103n spotr2=103n spobr2=103n
U203 (VDLY CODE203 VDLY VSS) nch_svt_mac l=16n nfin=2 w=58n multi=1 nf=8 \
        sd=74n sa=90n sb=90n ploda1=16n ploda2=0 ploda3=0 plodb1=16n \
        plodb2=0 plodb3=0 nf_flag=1 smbt=1M smbb=1M dinsaflag=0 ppitch=0 \
        spot=103n spob=103n spotl1=103n spobl1=103n spotl2=103n \
        spobl2=103n spotr1=103n spobr1=103n spotr2=103n spobr2=103n
U202 (VDLY CODE202 VDLY VSS) nch_svt_mac l=16n nfin=2 w=58n multi=1 nf=8 \
        sd=74n sa=90n sb=90n ploda1=16n ploda2=0 ploda3=0 plodb1=16n \
        plodb2=0 plodb3=0 nf_flag=1 smbt=1M smbb=1M dinsaflag=0 ppitch=0 \
        spot=103n spob=103n spotl1=103n spobl1=103n spotl2=103n \
        spobl2=103n spotr1=103n spobr1=103n spotr2=103n spobr2=103n
U201 (VDLY CODE201 VDLY VSS) nch_svt_mac l=16n nfin=2 w=58n multi=1 nf=8 \
        sd=74n sa=90n sb=90n ploda1=16n ploda2=0 ploda3=0 plodb1=16n \
        plodb2=0 plodb3=0 nf_flag=1 smbt=1M smbb=1M dinsaflag=0 ppitch=0 \
        spot=103n spob=103n spotl1=103n spobl1=103n spotl2=103n \
        spobl2=103n spotr1=103n spobr1=103n spotr2=103n spobr2=103n
U200 (VDLY CODE200 VDLY VSS) nch_svt_mac l=16n nfin=2 w=58n multi=1 nf=8 \
        sd=74n sa=90n sb=90n ploda1=16n ploda2=0 ploda3=0 plodb1=16n \
        plodb2=0 plodb3=0 nf_flag=1 smbt=1M smbb=1M dinsaflag=0 ppitch=0 \
        spot=103n spob=103n spotl1=103n spobl1=103n spotl2=103n \
        spobl2=103n spotr1=103n spobr1=103n spotr2=103n spobr2=103n
U199 (VDLY CODE199 VDLY VSS) nch_svt_mac l=16n nfin=2 w=58n multi=1 nf=8 \
        sd=74n sa=90n sb=90n ploda1=16n ploda2=0 ploda3=0 plodb1=16n \
        plodb2=0 plodb3=0 nf_flag=1 smbt=1M smbb=1M dinsaflag=0 ppitch=0 \
        spot=103n spob=103n spotl1=103n spobl1=103n spotl2=103n \
        spobl2=103n spotr1=103n spobr1=103n spotr2=103n spobr2=103n
U198 (VDLY CODE198 VDLY VSS) nch_svt_mac l=16n nfin=2 w=58n multi=1 nf=8 \
        sd=74n sa=90n sb=90n ploda1=16n ploda2=0 ploda3=0 plodb1=16n \
        plodb2=0 plodb3=0 nf_flag=1 smbt=1M smbb=1M dinsaflag=0 ppitch=0 \
        spot=103n spob=103n spotl1=103n spobl1=103n spotl2=103n \
        spobl2=103n spotr1=103n spobr1=103n spotr2=103n spobr2=103n
U197 (VDLY CODE197 VDLY VSS) nch_svt_mac l=16n nfin=2 w=58n multi=1 nf=8 \
        sd=74n sa=90n sb=90n ploda1=16n ploda2=0 ploda3=0 plodb1=16n \
        plodb2=0 plodb3=0 nf_flag=1 smbt=1M smbb=1M dinsaflag=0 ppitch=0 \
        spot=103n spob=103n spotl1=103n spobl1=103n spotl2=103n \
        spobl2=103n spotr1=103n spobr1=103n spotr2=103n spobr2=103n
U196 (VDLY CODE196 VDLY VSS) nch_svt_mac l=16n nfin=2 w=58n multi=1 nf=8 \
        sd=74n sa=90n sb=90n ploda1=16n ploda2=0 ploda3=0 plodb1=16n \
        plodb2=0 plodb3=0 nf_flag=1 smbt=1M smbb=1M dinsaflag=0 ppitch=0 \
        spot=103n spob=103n spotl1=103n spobl1=103n spotl2=103n \
        spobl2=103n spotr1=103n spobr1=103n spotr2=103n spobr2=103n
U195 (VDLY CODE195 VDLY VSS) nch_svt_mac l=16n nfin=2 w=58n multi=1 nf=8 \
        sd=74n sa=90n sb=90n ploda1=16n ploda2=0 ploda3=0 plodb1=16n \
        plodb2=0 plodb3=0 nf_flag=1 smbt=1M smbb=1M dinsaflag=0 ppitch=0 \
        spot=103n spob=103n spotl1=103n spobl1=103n spotl2=103n \
        spobl2=103n spotr1=103n spobr1=103n spotr2=103n spobr2=103n
U194 (VDLY CODE194 VDLY VSS) nch_svt_mac l=16n nfin=2 w=58n multi=1 nf=8 \
        sd=74n sa=90n sb=90n ploda1=16n ploda2=0 ploda3=0 plodb1=16n \
        plodb2=0 plodb3=0 nf_flag=1 smbt=1M smbb=1M dinsaflag=0 ppitch=0 \
        spot=103n spob=103n spotl1=103n spobl1=103n spotl2=103n \
        spobl2=103n spotr1=103n spobr1=103n spotr2=103n spobr2=103n
U193 (VDLY CODE193 VDLY VSS) nch_svt_mac l=16n nfin=2 w=58n multi=1 nf=8 \
        sd=74n sa=90n sb=90n ploda1=16n ploda2=0 ploda3=0 plodb1=16n \
        plodb2=0 plodb3=0 nf_flag=1 smbt=1M smbb=1M dinsaflag=0 ppitch=0 \
        spot=103n spob=103n spotl1=103n spobl1=103n spotl2=103n \
        spobl2=103n spotr1=103n spobr1=103n spotr2=103n spobr2=103n
U192 (VDLY CODE192 VDLY VSS) nch_svt_mac l=16n nfin=2 w=58n multi=1 nf=8 \
        sd=74n sa=90n sb=90n ploda1=16n ploda2=0 ploda3=0 plodb1=16n \
        plodb2=0 plodb3=0 nf_flag=1 smbt=1M smbb=1M dinsaflag=0 ppitch=0 \
        spot=103n spob=103n spotl1=103n spobl1=103n spotl2=103n \
        spobl2=103n spotr1=103n spobr1=103n spotr2=103n spobr2=103n
U191 (VDLY CODE191 VDLY VSS) nch_svt_mac l=16n nfin=2 w=58n multi=1 nf=8 \
        sd=74n sa=90n sb=90n ploda1=16n ploda2=0 ploda3=0 plodb1=16n \
        plodb2=0 plodb3=0 nf_flag=1 smbt=1M smbb=1M dinsaflag=0 ppitch=0 \
        spot=103n spob=103n spotl1=103n spobl1=103n spotl2=103n \
        spobl2=103n spotr1=103n spobr1=103n spotr2=103n spobr2=103n
U190 (VDLY CODE190 VDLY VSS) nch_svt_mac l=16n nfin=2 w=58n multi=1 nf=8 \
        sd=74n sa=90n sb=90n ploda1=16n ploda2=0 ploda3=0 plodb1=16n \
        plodb2=0 plodb3=0 nf_flag=1 smbt=1M smbb=1M dinsaflag=0 ppitch=0 \
        spot=103n spob=103n spotl1=103n spobl1=103n spotl2=103n \
        spobl2=103n spotr1=103n spobr1=103n spotr2=103n spobr2=103n
U189 (VDLY CODE189 VDLY VSS) nch_svt_mac l=16n nfin=2 w=58n multi=1 nf=8 \
        sd=74n sa=90n sb=90n ploda1=16n ploda2=0 ploda3=0 plodb1=16n \
        plodb2=0 plodb3=0 nf_flag=1 smbt=1M smbb=1M dinsaflag=0 ppitch=0 \
        spot=103n spob=103n spotl1=103n spobl1=103n spotl2=103n \
        spobl2=103n spotr1=103n spobr1=103n spotr2=103n spobr2=103n
U188 (VDLY CODE188 VDLY VSS) nch_svt_mac l=16n nfin=2 w=58n multi=1 nf=8 \
        sd=74n sa=90n sb=90n ploda1=16n ploda2=0 ploda3=0 plodb1=16n \
        plodb2=0 plodb3=0 nf_flag=1 smbt=1M smbb=1M dinsaflag=0 ppitch=0 \
        spot=103n spob=103n spotl1=103n spobl1=103n spotl2=103n \
        spobl2=103n spotr1=103n spobr1=103n spotr2=103n spobr2=103n
U187 (VDLY CODE187 VDLY VSS) nch_svt_mac l=16n nfin=2 w=58n multi=1 nf=8 \
        sd=74n sa=90n sb=90n ploda1=16n ploda2=0 ploda3=0 plodb1=16n \
        plodb2=0 plodb3=0 nf_flag=1 smbt=1M smbb=1M dinsaflag=0 ppitch=0 \
        spot=103n spob=103n spotl1=103n spobl1=103n spotl2=103n \
        spobl2=103n spotr1=103n spobr1=103n spotr2=103n spobr2=103n
U186 (VDLY CODE186 VDLY VSS) nch_svt_mac l=16n nfin=2 w=58n multi=1 nf=8 \
        sd=74n sa=90n sb=90n ploda1=16n ploda2=0 ploda3=0 plodb1=16n \
        plodb2=0 plodb3=0 nf_flag=1 smbt=1M smbb=1M dinsaflag=0 ppitch=0 \
        spot=103n spob=103n spotl1=103n spobl1=103n spotl2=103n \
        spobl2=103n spotr1=103n spobr1=103n spotr2=103n spobr2=103n
U185 (VDLY CODE185 VDLY VSS) nch_svt_mac l=16n nfin=2 w=58n multi=1 nf=8 \
        sd=74n sa=90n sb=90n ploda1=16n ploda2=0 ploda3=0 plodb1=16n \
        plodb2=0 plodb3=0 nf_flag=1 smbt=1M smbb=1M dinsaflag=0 ppitch=0 \
        spot=103n spob=103n spotl1=103n spobl1=103n spotl2=103n \
        spobl2=103n spotr1=103n spobr1=103n spotr2=103n spobr2=103n
U184 (VDLY CODE184 VDLY VSS) nch_svt_mac l=16n nfin=2 w=58n multi=1 nf=8 \
        sd=74n sa=90n sb=90n ploda1=16n ploda2=0 ploda3=0 plodb1=16n \
        plodb2=0 plodb3=0 nf_flag=1 smbt=1M smbb=1M dinsaflag=0 ppitch=0 \
        spot=103n spob=103n spotl1=103n spobl1=103n spotl2=103n \
        spobl2=103n spotr1=103n spobr1=103n spotr2=103n spobr2=103n
U183 (VDLY CODE183 VDLY VSS) nch_svt_mac l=16n nfin=2 w=58n multi=1 nf=8 \
        sd=74n sa=90n sb=90n ploda1=16n ploda2=0 ploda3=0 plodb1=16n \
        plodb2=0 plodb3=0 nf_flag=1 smbt=1M smbb=1M dinsaflag=0 ppitch=0 \
        spot=103n spob=103n spotl1=103n spobl1=103n spotl2=103n \
        spobl2=103n spotr1=103n spobr1=103n spotr2=103n spobr2=103n
U182 (VDLY CODE182 VDLY VSS) nch_svt_mac l=16n nfin=2 w=58n multi=1 nf=8 \
        sd=74n sa=90n sb=90n ploda1=16n ploda2=0 ploda3=0 plodb1=16n \
        plodb2=0 plodb3=0 nf_flag=1 smbt=1M smbb=1M dinsaflag=0 ppitch=0 \
        spot=103n spob=103n spotl1=103n spobl1=103n spotl2=103n \
        spobl2=103n spotr1=103n spobr1=103n spotr2=103n spobr2=103n
U181 (VDLY CODE181 VDLY VSS) nch_svt_mac l=16n nfin=2 w=58n multi=1 nf=8 \
        sd=74n sa=90n sb=90n ploda1=16n ploda2=0 ploda3=0 plodb1=16n \
        plodb2=0 plodb3=0 nf_flag=1 smbt=1M smbb=1M dinsaflag=0 ppitch=0 \
        spot=103n spob=103n spotl1=103n spobl1=103n spotl2=103n \
        spobl2=103n spotr1=103n spobr1=103n spotr2=103n spobr2=103n
U180 (VDLY CODE180 VDLY VSS) nch_svt_mac l=16n nfin=2 w=58n multi=1 nf=8 \
        sd=74n sa=90n sb=90n ploda1=16n ploda2=0 ploda3=0 plodb1=16n \
        plodb2=0 plodb3=0 nf_flag=1 smbt=1M smbb=1M dinsaflag=0 ppitch=0 \
        spot=103n spob=103n spotl1=103n spobl1=103n spotl2=103n \
        spobl2=103n spotr1=103n spobr1=103n spotr2=103n spobr2=103n
U179 (VDLY CODE179 VDLY VSS) nch_svt_mac l=16n nfin=2 w=58n multi=1 nf=8 \
        sd=74n sa=90n sb=90n ploda1=16n ploda2=0 ploda3=0 plodb1=16n \
        plodb2=0 plodb3=0 nf_flag=1 smbt=1M smbb=1M dinsaflag=0 ppitch=0 \
        spot=103n spob=103n spotl1=103n spobl1=103n spotl2=103n \
        spobl2=103n spotr1=103n spobr1=103n spotr2=103n spobr2=103n
U178 (VDLY CODE178 VDLY VSS) nch_svt_mac l=16n nfin=2 w=58n multi=1 nf=8 \
        sd=74n sa=90n sb=90n ploda1=16n ploda2=0 ploda3=0 plodb1=16n \
        plodb2=0 plodb3=0 nf_flag=1 smbt=1M smbb=1M dinsaflag=0 ppitch=0 \
        spot=103n spob=103n spotl1=103n spobl1=103n spotl2=103n \
        spobl2=103n spotr1=103n spobr1=103n spotr2=103n spobr2=103n
U177 (VDLY CODE177 VDLY VSS) nch_svt_mac l=16n nfin=2 w=58n multi=1 nf=8 \
        sd=74n sa=90n sb=90n ploda1=16n ploda2=0 ploda3=0 plodb1=16n \
        plodb2=0 plodb3=0 nf_flag=1 smbt=1M smbb=1M dinsaflag=0 ppitch=0 \
        spot=103n spob=103n spotl1=103n spobl1=103n spotl2=103n \
        spobl2=103n spotr1=103n spobr1=103n spotr2=103n spobr2=103n
U176 (VDLY CODE176 VDLY VSS) nch_svt_mac l=16n nfin=2 w=58n multi=1 nf=8 \
        sd=74n sa=90n sb=90n ploda1=16n ploda2=0 ploda3=0 plodb1=16n \
        plodb2=0 plodb3=0 nf_flag=1 smbt=1M smbb=1M dinsaflag=0 ppitch=0 \
        spot=103n spob=103n spotl1=103n spobl1=103n spotl2=103n \
        spobl2=103n spotr1=103n spobr1=103n spotr2=103n spobr2=103n
U175 (VDLY CODE175 VDLY VSS) nch_svt_mac l=16n nfin=2 w=58n multi=1 nf=8 \
        sd=74n sa=90n sb=90n ploda1=16n ploda2=0 ploda3=0 plodb1=16n \
        plodb2=0 plodb3=0 nf_flag=1 smbt=1M smbb=1M dinsaflag=0 ppitch=0 \
        spot=103n spob=103n spotl1=103n spobl1=103n spotl2=103n \
        spobl2=103n spotr1=103n spobr1=103n spotr2=103n spobr2=103n
U174 (VDLY CODE174 VDLY VSS) nch_svt_mac l=16n nfin=2 w=58n multi=1 nf=8 \
        sd=74n sa=90n sb=90n ploda1=16n ploda2=0 ploda3=0 plodb1=16n \
        plodb2=0 plodb3=0 nf_flag=1 smbt=1M smbb=1M dinsaflag=0 ppitch=0 \
        spot=103n spob=103n spotl1=103n spobl1=103n spotl2=103n \
        spobl2=103n spotr1=103n spobr1=103n spotr2=103n spobr2=103n
U173 (VDLY CODE173 VDLY VSS) nch_svt_mac l=16n nfin=2 w=58n multi=1 nf=8 \
        sd=74n sa=90n sb=90n ploda1=16n ploda2=0 ploda3=0 plodb1=16n \
        plodb2=0 plodb3=0 nf_flag=1 smbt=1M smbb=1M dinsaflag=0 ppitch=0 \
        spot=103n spob=103n spotl1=103n spobl1=103n spotl2=103n \
        spobl2=103n spotr1=103n spobr1=103n spotr2=103n spobr2=103n
U172 (VDLY CODE172 VDLY VSS) nch_svt_mac l=16n nfin=2 w=58n multi=1 nf=8 \
        sd=74n sa=90n sb=90n ploda1=16n ploda2=0 ploda3=0 plodb1=16n \
        plodb2=0 plodb3=0 nf_flag=1 smbt=1M smbb=1M dinsaflag=0 ppitch=0 \
        spot=103n spob=103n spotl1=103n spobl1=103n spotl2=103n \
        spobl2=103n spotr1=103n spobr1=103n spotr2=103n spobr2=103n
U171 (VDLY CODE171 VDLY VSS) nch_svt_mac l=16n nfin=2 w=58n multi=1 nf=8 \
        sd=74n sa=90n sb=90n ploda1=16n ploda2=0 ploda3=0 plodb1=16n \
        plodb2=0 plodb3=0 nf_flag=1 smbt=1M smbb=1M dinsaflag=0 ppitch=0 \
        spot=103n spob=103n spotl1=103n spobl1=103n spotl2=103n \
        spobl2=103n spotr1=103n spobr1=103n spotr2=103n spobr2=103n
U170 (VDLY CODE170 VDLY VSS) nch_svt_mac l=16n nfin=2 w=58n multi=1 nf=8 \
        sd=74n sa=90n sb=90n ploda1=16n ploda2=0 ploda3=0 plodb1=16n \
        plodb2=0 plodb3=0 nf_flag=1 smbt=1M smbb=1M dinsaflag=0 ppitch=0 \
        spot=103n spob=103n spotl1=103n spobl1=103n spotl2=103n \
        spobl2=103n spotr1=103n spobr1=103n spotr2=103n spobr2=103n
U169 (VDLY CODE169 VDLY VSS) nch_svt_mac l=16n nfin=2 w=58n multi=1 nf=8 \
        sd=74n sa=90n sb=90n ploda1=16n ploda2=0 ploda3=0 plodb1=16n \
        plodb2=0 plodb3=0 nf_flag=1 smbt=1M smbb=1M dinsaflag=0 ppitch=0 \
        spot=103n spob=103n spotl1=103n spobl1=103n spotl2=103n \
        spobl2=103n spotr1=103n spobr1=103n spotr2=103n spobr2=103n
U168 (VDLY CODE168 VDLY VSS) nch_svt_mac l=16n nfin=2 w=58n multi=1 nf=8 \
        sd=74n sa=90n sb=90n ploda1=16n ploda2=0 ploda3=0 plodb1=16n \
        plodb2=0 plodb3=0 nf_flag=1 smbt=1M smbb=1M dinsaflag=0 ppitch=0 \
        spot=103n spob=103n spotl1=103n spobl1=103n spotl2=103n \
        spobl2=103n spotr1=103n spobr1=103n spotr2=103n spobr2=103n
U167 (VDLY CODE167 VDLY VSS) nch_svt_mac l=16n nfin=2 w=58n multi=1 nf=8 \
        sd=74n sa=90n sb=90n ploda1=16n ploda2=0 ploda3=0 plodb1=16n \
        plodb2=0 plodb3=0 nf_flag=1 smbt=1M smbb=1M dinsaflag=0 ppitch=0 \
        spot=103n spob=103n spotl1=103n spobl1=103n spotl2=103n \
        spobl2=103n spotr1=103n spobr1=103n spotr2=103n spobr2=103n
U166 (VDLY CODE166 VDLY VSS) nch_svt_mac l=16n nfin=2 w=58n multi=1 nf=8 \
        sd=74n sa=90n sb=90n ploda1=16n ploda2=0 ploda3=0 plodb1=16n \
        plodb2=0 plodb3=0 nf_flag=1 smbt=1M smbb=1M dinsaflag=0 ppitch=0 \
        spot=103n spob=103n spotl1=103n spobl1=103n spotl2=103n \
        spobl2=103n spotr1=103n spobr1=103n spotr2=103n spobr2=103n
U165 (VDLY CODE165 VDLY VSS) nch_svt_mac l=16n nfin=2 w=58n multi=1 nf=8 \
        sd=74n sa=90n sb=90n ploda1=16n ploda2=0 ploda3=0 plodb1=16n \
        plodb2=0 plodb3=0 nf_flag=1 smbt=1M smbb=1M dinsaflag=0 ppitch=0 \
        spot=103n spob=103n spotl1=103n spobl1=103n spotl2=103n \
        spobl2=103n spotr1=103n spobr1=103n spotr2=103n spobr2=103n
U164 (VDLY CODE164 VDLY VSS) nch_svt_mac l=16n nfin=2 w=58n multi=1 nf=8 \
        sd=74n sa=90n sb=90n ploda1=16n ploda2=0 ploda3=0 plodb1=16n \
        plodb2=0 plodb3=0 nf_flag=1 smbt=1M smbb=1M dinsaflag=0 ppitch=0 \
        spot=103n spob=103n spotl1=103n spobl1=103n spotl2=103n \
        spobl2=103n spotr1=103n spobr1=103n spotr2=103n spobr2=103n
U163 (VDLY CODE163 VDLY VSS) nch_svt_mac l=16n nfin=2 w=58n multi=1 nf=8 \
        sd=74n sa=90n sb=90n ploda1=16n ploda2=0 ploda3=0 plodb1=16n \
        plodb2=0 plodb3=0 nf_flag=1 smbt=1M smbb=1M dinsaflag=0 ppitch=0 \
        spot=103n spob=103n spotl1=103n spobl1=103n spotl2=103n \
        spobl2=103n spotr1=103n spobr1=103n spotr2=103n spobr2=103n
U162 (VDLY CODE162 VDLY VSS) nch_svt_mac l=16n nfin=2 w=58n multi=1 nf=8 \
        sd=74n sa=90n sb=90n ploda1=16n ploda2=0 ploda3=0 plodb1=16n \
        plodb2=0 plodb3=0 nf_flag=1 smbt=1M smbb=1M dinsaflag=0 ppitch=0 \
        spot=103n spob=103n spotl1=103n spobl1=103n spotl2=103n \
        spobl2=103n spotr1=103n spobr1=103n spotr2=103n spobr2=103n
U161 (VDLY CODE161 VDLY VSS) nch_svt_mac l=16n nfin=2 w=58n multi=1 nf=8 \
        sd=74n sa=90n sb=90n ploda1=16n ploda2=0 ploda3=0 plodb1=16n \
        plodb2=0 plodb3=0 nf_flag=1 smbt=1M smbb=1M dinsaflag=0 ppitch=0 \
        spot=103n spob=103n spotl1=103n spobl1=103n spotl2=103n \
        spobl2=103n spotr1=103n spobr1=103n spotr2=103n spobr2=103n
U160 (VDLY CODE160 VDLY VSS) nch_svt_mac l=16n nfin=2 w=58n multi=1 nf=8 \
        sd=74n sa=90n sb=90n ploda1=16n ploda2=0 ploda3=0 plodb1=16n \
        plodb2=0 plodb3=0 nf_flag=1 smbt=1M smbb=1M dinsaflag=0 ppitch=0 \
        spot=103n spob=103n spotl1=103n spobl1=103n spotl2=103n \
        spobl2=103n spotr1=103n spobr1=103n spotr2=103n spobr2=103n
U159 (VDLY CODE159 VDLY VSS) nch_svt_mac l=16n nfin=2 w=58n multi=1 nf=8 \
        sd=74n sa=90n sb=90n ploda1=16n ploda2=0 ploda3=0 plodb1=16n \
        plodb2=0 plodb3=0 nf_flag=1 smbt=1M smbb=1M dinsaflag=0 ppitch=0 \
        spot=103n spob=103n spotl1=103n spobl1=103n spotl2=103n \
        spobl2=103n spotr1=103n spobr1=103n spotr2=103n spobr2=103n
U158 (VDLY CODE158 VDLY VSS) nch_svt_mac l=16n nfin=2 w=58n multi=1 nf=8 \
        sd=74n sa=90n sb=90n ploda1=16n ploda2=0 ploda3=0 plodb1=16n \
        plodb2=0 plodb3=0 nf_flag=1 smbt=1M smbb=1M dinsaflag=0 ppitch=0 \
        spot=103n spob=103n spotl1=103n spobl1=103n spotl2=103n \
        spobl2=103n spotr1=103n spobr1=103n spotr2=103n spobr2=103n
U157 (VDLY CODE157 VDLY VSS) nch_svt_mac l=16n nfin=2 w=58n multi=1 nf=8 \
        sd=74n sa=90n sb=90n ploda1=16n ploda2=0 ploda3=0 plodb1=16n \
        plodb2=0 plodb3=0 nf_flag=1 smbt=1M smbb=1M dinsaflag=0 ppitch=0 \
        spot=103n spob=103n spotl1=103n spobl1=103n spotl2=103n \
        spobl2=103n spotr1=103n spobr1=103n spotr2=103n spobr2=103n
U156 (VDLY CODE156 VDLY VSS) nch_svt_mac l=16n nfin=2 w=58n multi=1 nf=8 \
        sd=74n sa=90n sb=90n ploda1=16n ploda2=0 ploda3=0 plodb1=16n \
        plodb2=0 plodb3=0 nf_flag=1 smbt=1M smbb=1M dinsaflag=0 ppitch=0 \
        spot=103n spob=103n spotl1=103n spobl1=103n spotl2=103n \
        spobl2=103n spotr1=103n spobr1=103n spotr2=103n spobr2=103n
U155 (VDLY CODE155 VDLY VSS) nch_svt_mac l=16n nfin=2 w=58n multi=1 nf=8 \
        sd=74n sa=90n sb=90n ploda1=16n ploda2=0 ploda3=0 plodb1=16n \
        plodb2=0 plodb3=0 nf_flag=1 smbt=1M smbb=1M dinsaflag=0 ppitch=0 \
        spot=103n spob=103n spotl1=103n spobl1=103n spotl2=103n \
        spobl2=103n spotr1=103n spobr1=103n spotr2=103n spobr2=103n
U154 (VDLY CODE154 VDLY VSS) nch_svt_mac l=16n nfin=2 w=58n multi=1 nf=8 \
        sd=74n sa=90n sb=90n ploda1=16n ploda2=0 ploda3=0 plodb1=16n \
        plodb2=0 plodb3=0 nf_flag=1 smbt=1M smbb=1M dinsaflag=0 ppitch=0 \
        spot=103n spob=103n spotl1=103n spobl1=103n spotl2=103n \
        spobl2=103n spotr1=103n spobr1=103n spotr2=103n spobr2=103n
U153 (VDLY CODE153 VDLY VSS) nch_svt_mac l=16n nfin=2 w=58n multi=1 nf=8 \
        sd=74n sa=90n sb=90n ploda1=16n ploda2=0 ploda3=0 plodb1=16n \
        plodb2=0 plodb3=0 nf_flag=1 smbt=1M smbb=1M dinsaflag=0 ppitch=0 \
        spot=103n spob=103n spotl1=103n spobl1=103n spotl2=103n \
        spobl2=103n spotr1=103n spobr1=103n spotr2=103n spobr2=103n
U152 (VDLY CODE152 VDLY VSS) nch_svt_mac l=16n nfin=2 w=58n multi=1 nf=8 \
        sd=74n sa=90n sb=90n ploda1=16n ploda2=0 ploda3=0 plodb1=16n \
        plodb2=0 plodb3=0 nf_flag=1 smbt=1M smbb=1M dinsaflag=0 ppitch=0 \
        spot=103n spob=103n spotl1=103n spobl1=103n spotl2=103n \
        spobl2=103n spotr1=103n spobr1=103n spotr2=103n spobr2=103n
U151 (VDLY CODE151 VDLY VSS) nch_svt_mac l=16n nfin=2 w=58n multi=1 nf=8 \
        sd=74n sa=90n sb=90n ploda1=16n ploda2=0 ploda3=0 plodb1=16n \
        plodb2=0 plodb3=0 nf_flag=1 smbt=1M smbb=1M dinsaflag=0 ppitch=0 \
        spot=103n spob=103n spotl1=103n spobl1=103n spotl2=103n \
        spobl2=103n spotr1=103n spobr1=103n spotr2=103n spobr2=103n
U150 (VDLY CODE150 VDLY VSS) nch_svt_mac l=16n nfin=2 w=58n multi=1 nf=8 \
        sd=74n sa=90n sb=90n ploda1=16n ploda2=0 ploda3=0 plodb1=16n \
        plodb2=0 plodb3=0 nf_flag=1 smbt=1M smbb=1M dinsaflag=0 ppitch=0 \
        spot=103n spob=103n spotl1=103n spobl1=103n spotl2=103n \
        spobl2=103n spotr1=103n spobr1=103n spotr2=103n spobr2=103n
U149 (VDLY CODE149 VDLY VSS) nch_svt_mac l=16n nfin=2 w=58n multi=1 nf=8 \
        sd=74n sa=90n sb=90n ploda1=16n ploda2=0 ploda3=0 plodb1=16n \
        plodb2=0 plodb3=0 nf_flag=1 smbt=1M smbb=1M dinsaflag=0 ppitch=0 \
        spot=103n spob=103n spotl1=103n spobl1=103n spotl2=103n \
        spobl2=103n spotr1=103n spobr1=103n spotr2=103n spobr2=103n
U148 (VDLY CODE148 VDLY VSS) nch_svt_mac l=16n nfin=2 w=58n multi=1 nf=8 \
        sd=74n sa=90n sb=90n ploda1=16n ploda2=0 ploda3=0 plodb1=16n \
        plodb2=0 plodb3=0 nf_flag=1 smbt=1M smbb=1M dinsaflag=0 ppitch=0 \
        spot=103n spob=103n spotl1=103n spobl1=103n spotl2=103n \
        spobl2=103n spotr1=103n spobr1=103n spotr2=103n spobr2=103n
U147 (VDLY CODE147 VDLY VSS) nch_svt_mac l=16n nfin=2 w=58n multi=1 nf=8 \
        sd=74n sa=90n sb=90n ploda1=16n ploda2=0 ploda3=0 plodb1=16n \
        plodb2=0 plodb3=0 nf_flag=1 smbt=1M smbb=1M dinsaflag=0 ppitch=0 \
        spot=103n spob=103n spotl1=103n spobl1=103n spotl2=103n \
        spobl2=103n spotr1=103n spobr1=103n spotr2=103n spobr2=103n
U146 (VDLY CODE146 VDLY VSS) nch_svt_mac l=16n nfin=2 w=58n multi=1 nf=8 \
        sd=74n sa=90n sb=90n ploda1=16n ploda2=0 ploda3=0 plodb1=16n \
        plodb2=0 plodb3=0 nf_flag=1 smbt=1M smbb=1M dinsaflag=0 ppitch=0 \
        spot=103n spob=103n spotl1=103n spobl1=103n spotl2=103n \
        spobl2=103n spotr1=103n spobr1=103n spotr2=103n spobr2=103n
U145 (VDLY CODE145 VDLY VSS) nch_svt_mac l=16n nfin=2 w=58n multi=1 nf=8 \
        sd=74n sa=90n sb=90n ploda1=16n ploda2=0 ploda3=0 plodb1=16n \
        plodb2=0 plodb3=0 nf_flag=1 smbt=1M smbb=1M dinsaflag=0 ppitch=0 \
        spot=103n spob=103n spotl1=103n spobl1=103n spotl2=103n \
        spobl2=103n spotr1=103n spobr1=103n spotr2=103n spobr2=103n
U144 (VDLY CODE144 VDLY VSS) nch_svt_mac l=16n nfin=2 w=58n multi=1 nf=8 \
        sd=74n sa=90n sb=90n ploda1=16n ploda2=0 ploda3=0 plodb1=16n \
        plodb2=0 plodb3=0 nf_flag=1 smbt=1M smbb=1M dinsaflag=0 ppitch=0 \
        spot=103n spob=103n spotl1=103n spobl1=103n spotl2=103n \
        spobl2=103n spotr1=103n spobr1=103n spotr2=103n spobr2=103n
U143 (VDLY CODE143 VDLY VSS) nch_svt_mac l=16n nfin=2 w=58n multi=1 nf=8 \
        sd=74n sa=90n sb=90n ploda1=16n ploda2=0 ploda3=0 plodb1=16n \
        plodb2=0 plodb3=0 nf_flag=1 smbt=1M smbb=1M dinsaflag=0 ppitch=0 \
        spot=103n spob=103n spotl1=103n spobl1=103n spotl2=103n \
        spobl2=103n spotr1=103n spobr1=103n spotr2=103n spobr2=103n
U142 (VDLY CODE142 VDLY VSS) nch_svt_mac l=16n nfin=2 w=58n multi=1 nf=8 \
        sd=74n sa=90n sb=90n ploda1=16n ploda2=0 ploda3=0 plodb1=16n \
        plodb2=0 plodb3=0 nf_flag=1 smbt=1M smbb=1M dinsaflag=0 ppitch=0 \
        spot=103n spob=103n spotl1=103n spobl1=103n spotl2=103n \
        spobl2=103n spotr1=103n spobr1=103n spotr2=103n spobr2=103n
U141 (VDLY CODE141 VDLY VSS) nch_svt_mac l=16n nfin=2 w=58n multi=1 nf=8 \
        sd=74n sa=90n sb=90n ploda1=16n ploda2=0 ploda3=0 plodb1=16n \
        plodb2=0 plodb3=0 nf_flag=1 smbt=1M smbb=1M dinsaflag=0 ppitch=0 \
        spot=103n spob=103n spotl1=103n spobl1=103n spotl2=103n \
        spobl2=103n spotr1=103n spobr1=103n spotr2=103n spobr2=103n
U140 (VDLY CODE140 VDLY VSS) nch_svt_mac l=16n nfin=2 w=58n multi=1 nf=8 \
        sd=74n sa=90n sb=90n ploda1=16n ploda2=0 ploda3=0 plodb1=16n \
        plodb2=0 plodb3=0 nf_flag=1 smbt=1M smbb=1M dinsaflag=0 ppitch=0 \
        spot=103n spob=103n spotl1=103n spobl1=103n spotl2=103n \
        spobl2=103n spotr1=103n spobr1=103n spotr2=103n spobr2=103n
U139 (VDLY CODE139 VDLY VSS) nch_svt_mac l=16n nfin=2 w=58n multi=1 nf=8 \
        sd=74n sa=90n sb=90n ploda1=16n ploda2=0 ploda3=0 plodb1=16n \
        plodb2=0 plodb3=0 nf_flag=1 smbt=1M smbb=1M dinsaflag=0 ppitch=0 \
        spot=103n spob=103n spotl1=103n spobl1=103n spotl2=103n \
        spobl2=103n spotr1=103n spobr1=103n spotr2=103n spobr2=103n
U138 (VDLY CODE138 VDLY VSS) nch_svt_mac l=16n nfin=2 w=58n multi=1 nf=8 \
        sd=74n sa=90n sb=90n ploda1=16n ploda2=0 ploda3=0 plodb1=16n \
        plodb2=0 plodb3=0 nf_flag=1 smbt=1M smbb=1M dinsaflag=0 ppitch=0 \
        spot=103n spob=103n spotl1=103n spobl1=103n spotl2=103n \
        spobl2=103n spotr1=103n spobr1=103n spotr2=103n spobr2=103n
U137 (VDLY CODE137 VDLY VSS) nch_svt_mac l=16n nfin=2 w=58n multi=1 nf=8 \
        sd=74n sa=90n sb=90n ploda1=16n ploda2=0 ploda3=0 plodb1=16n \
        plodb2=0 plodb3=0 nf_flag=1 smbt=1M smbb=1M dinsaflag=0 ppitch=0 \
        spot=103n spob=103n spotl1=103n spobl1=103n spotl2=103n \
        spobl2=103n spotr1=103n spobr1=103n spotr2=103n spobr2=103n
U136 (VDLY CODE136 VDLY VSS) nch_svt_mac l=16n nfin=2 w=58n multi=1 nf=8 \
        sd=74n sa=90n sb=90n ploda1=16n ploda2=0 ploda3=0 plodb1=16n \
        plodb2=0 plodb3=0 nf_flag=1 smbt=1M smbb=1M dinsaflag=0 ppitch=0 \
        spot=103n spob=103n spotl1=103n spobl1=103n spotl2=103n \
        spobl2=103n spotr1=103n spobr1=103n spotr2=103n spobr2=103n
U135 (VDLY CODE135 VDLY VSS) nch_svt_mac l=16n nfin=2 w=58n multi=1 nf=8 \
        sd=74n sa=90n sb=90n ploda1=16n ploda2=0 ploda3=0 plodb1=16n \
        plodb2=0 plodb3=0 nf_flag=1 smbt=1M smbb=1M dinsaflag=0 ppitch=0 \
        spot=103n spob=103n spotl1=103n spobl1=103n spotl2=103n \
        spobl2=103n spotr1=103n spobr1=103n spotr2=103n spobr2=103n
U134 (VDLY CODE134 VDLY VSS) nch_svt_mac l=16n nfin=2 w=58n multi=1 nf=8 \
        sd=74n sa=90n sb=90n ploda1=16n ploda2=0 ploda3=0 plodb1=16n \
        plodb2=0 plodb3=0 nf_flag=1 smbt=1M smbb=1M dinsaflag=0 ppitch=0 \
        spot=103n spob=103n spotl1=103n spobl1=103n spotl2=103n \
        spobl2=103n spotr1=103n spobr1=103n spotr2=103n spobr2=103n
U133 (VDLY CODE133 VDLY VSS) nch_svt_mac l=16n nfin=2 w=58n multi=1 nf=8 \
        sd=74n sa=90n sb=90n ploda1=16n ploda2=0 ploda3=0 plodb1=16n \
        plodb2=0 plodb3=0 nf_flag=1 smbt=1M smbb=1M dinsaflag=0 ppitch=0 \
        spot=103n spob=103n spotl1=103n spobl1=103n spotl2=103n \
        spobl2=103n spotr1=103n spobr1=103n spotr2=103n spobr2=103n
U132 (VDLY CODE132 VDLY VSS) nch_svt_mac l=16n nfin=2 w=58n multi=1 nf=8 \
        sd=74n sa=90n sb=90n ploda1=16n ploda2=0 ploda3=0 plodb1=16n \
        plodb2=0 plodb3=0 nf_flag=1 smbt=1M smbb=1M dinsaflag=0 ppitch=0 \
        spot=103n spob=103n spotl1=103n spobl1=103n spotl2=103n \
        spobl2=103n spotr1=103n spobr1=103n spotr2=103n spobr2=103n
U131 (VDLY CODE131 VDLY VSS) nch_svt_mac l=16n nfin=2 w=58n multi=1 nf=8 \
        sd=74n sa=90n sb=90n ploda1=16n ploda2=0 ploda3=0 plodb1=16n \
        plodb2=0 plodb3=0 nf_flag=1 smbt=1M smbb=1M dinsaflag=0 ppitch=0 \
        spot=103n spob=103n spotl1=103n spobl1=103n spotl2=103n \
        spobl2=103n spotr1=103n spobr1=103n spotr2=103n spobr2=103n
U130 (VDLY CODE130 VDLY VSS) nch_svt_mac l=16n nfin=2 w=58n multi=1 nf=8 \
        sd=74n sa=90n sb=90n ploda1=16n ploda2=0 ploda3=0 plodb1=16n \
        plodb2=0 plodb3=0 nf_flag=1 smbt=1M smbb=1M dinsaflag=0 ppitch=0 \
        spot=103n spob=103n spotl1=103n spobl1=103n spotl2=103n \
        spobl2=103n spotr1=103n spobr1=103n spotr2=103n spobr2=103n
U129 (VDLY CODE129 VDLY VSS) nch_svt_mac l=16n nfin=2 w=58n multi=1 nf=8 \
        sd=74n sa=90n sb=90n ploda1=16n ploda2=0 ploda3=0 plodb1=16n \
        plodb2=0 plodb3=0 nf_flag=1 smbt=1M smbb=1M dinsaflag=0 ppitch=0 \
        spot=103n spob=103n spotl1=103n spobl1=103n spotl2=103n \
        spobl2=103n spotr1=103n spobr1=103n spotr2=103n spobr2=103n
U128 (VDLY CODE128 VDLY VSS) nch_svt_mac l=16n nfin=2 w=58n multi=1 nf=8 \
        sd=74n sa=90n sb=90n ploda1=16n ploda2=0 ploda3=0 plodb1=16n \
        plodb2=0 plodb3=0 nf_flag=1 smbt=1M smbb=1M dinsaflag=0 ppitch=0 \
        spot=103n spob=103n spotl1=103n spobl1=103n spotl2=103n \
        spobl2=103n spotr1=103n spobr1=103n spotr2=103n spobr2=103n
U127 (VDLY CODE127 VDLY VSS) nch_svt_mac l=16n nfin=2 w=58n multi=1 nf=8 \
        sd=74n sa=90n sb=90n ploda1=16n ploda2=0 ploda3=0 plodb1=16n \
        plodb2=0 plodb3=0 nf_flag=1 smbt=1M smbb=1M dinsaflag=0 ppitch=0 \
        spot=103n spob=103n spotl1=103n spobl1=103n spotl2=103n \
        spobl2=103n spotr1=103n spobr1=103n spotr2=103n spobr2=103n
U126 (VDLY CODE126 VDLY VSS) nch_svt_mac l=16n nfin=2 w=58n multi=1 nf=8 \
        sd=74n sa=90n sb=90n ploda1=16n ploda2=0 ploda3=0 plodb1=16n \
        plodb2=0 plodb3=0 nf_flag=1 smbt=1M smbb=1M dinsaflag=0 ppitch=0 \
        spot=103n spob=103n spotl1=103n spobl1=103n spotl2=103n \
        spobl2=103n spotr1=103n spobr1=103n spotr2=103n spobr2=103n
U125 (VDLY CODE125 VDLY VSS) nch_svt_mac l=16n nfin=2 w=58n multi=1 nf=8 \
        sd=74n sa=90n sb=90n ploda1=16n ploda2=0 ploda3=0 plodb1=16n \
        plodb2=0 plodb3=0 nf_flag=1 smbt=1M smbb=1M dinsaflag=0 ppitch=0 \
        spot=103n spob=103n spotl1=103n spobl1=103n spotl2=103n \
        spobl2=103n spotr1=103n spobr1=103n spotr2=103n spobr2=103n
U124 (VDLY CODE124 VDLY VSS) nch_svt_mac l=16n nfin=2 w=58n multi=1 nf=8 \
        sd=74n sa=90n sb=90n ploda1=16n ploda2=0 ploda3=0 plodb1=16n \
        plodb2=0 plodb3=0 nf_flag=1 smbt=1M smbb=1M dinsaflag=0 ppitch=0 \
        spot=103n spob=103n spotl1=103n spobl1=103n spotl2=103n \
        spobl2=103n spotr1=103n spobr1=103n spotr2=103n spobr2=103n
U123 (VDLY CODE123 VDLY VSS) nch_svt_mac l=16n nfin=2 w=58n multi=1 nf=8 \
        sd=74n sa=90n sb=90n ploda1=16n ploda2=0 ploda3=0 plodb1=16n \
        plodb2=0 plodb3=0 nf_flag=1 smbt=1M smbb=1M dinsaflag=0 ppitch=0 \
        spot=103n spob=103n spotl1=103n spobl1=103n spotl2=103n \
        spobl2=103n spotr1=103n spobr1=103n spotr2=103n spobr2=103n
U122 (VDLY CODE122 VDLY VSS) nch_svt_mac l=16n nfin=2 w=58n multi=1 nf=8 \
        sd=74n sa=90n sb=90n ploda1=16n ploda2=0 ploda3=0 plodb1=16n \
        plodb2=0 plodb3=0 nf_flag=1 smbt=1M smbb=1M dinsaflag=0 ppitch=0 \
        spot=103n spob=103n spotl1=103n spobl1=103n spotl2=103n \
        spobl2=103n spotr1=103n spobr1=103n spotr2=103n spobr2=103n
U121 (VDLY CODE121 VDLY VSS) nch_svt_mac l=16n nfin=2 w=58n multi=1 nf=8 \
        sd=74n sa=90n sb=90n ploda1=16n ploda2=0 ploda3=0 plodb1=16n \
        plodb2=0 plodb3=0 nf_flag=1 smbt=1M smbb=1M dinsaflag=0 ppitch=0 \
        spot=103n spob=103n spotl1=103n spobl1=103n spotl2=103n \
        spobl2=103n spotr1=103n spobr1=103n spotr2=103n spobr2=103n
U120 (VDLY CODE120 VDLY VSS) nch_svt_mac l=16n nfin=2 w=58n multi=1 nf=8 \
        sd=74n sa=90n sb=90n ploda1=16n ploda2=0 ploda3=0 plodb1=16n \
        plodb2=0 plodb3=0 nf_flag=1 smbt=1M smbb=1M dinsaflag=0 ppitch=0 \
        spot=103n spob=103n spotl1=103n spobl1=103n spotl2=103n \
        spobl2=103n spotr1=103n spobr1=103n spotr2=103n spobr2=103n
U119 (VDLY CODE119 VDLY VSS) nch_svt_mac l=16n nfin=2 w=58n multi=1 nf=8 \
        sd=74n sa=90n sb=90n ploda1=16n ploda2=0 ploda3=0 plodb1=16n \
        plodb2=0 plodb3=0 nf_flag=1 smbt=1M smbb=1M dinsaflag=0 ppitch=0 \
        spot=103n spob=103n spotl1=103n spobl1=103n spotl2=103n \
        spobl2=103n spotr1=103n spobr1=103n spotr2=103n spobr2=103n
U118 (VDLY CODE118 VDLY VSS) nch_svt_mac l=16n nfin=2 w=58n multi=1 nf=8 \
        sd=74n sa=90n sb=90n ploda1=16n ploda2=0 ploda3=0 plodb1=16n \
        plodb2=0 plodb3=0 nf_flag=1 smbt=1M smbb=1M dinsaflag=0 ppitch=0 \
        spot=103n spob=103n spotl1=103n spobl1=103n spotl2=103n \
        spobl2=103n spotr1=103n spobr1=103n spotr2=103n spobr2=103n
U117 (VDLY CODE117 VDLY VSS) nch_svt_mac l=16n nfin=2 w=58n multi=1 nf=8 \
        sd=74n sa=90n sb=90n ploda1=16n ploda2=0 ploda3=0 plodb1=16n \
        plodb2=0 plodb3=0 nf_flag=1 smbt=1M smbb=1M dinsaflag=0 ppitch=0 \
        spot=103n spob=103n spotl1=103n spobl1=103n spotl2=103n \
        spobl2=103n spotr1=103n spobr1=103n spotr2=103n spobr2=103n
U116 (VDLY CODE116 VDLY VSS) nch_svt_mac l=16n nfin=2 w=58n multi=1 nf=8 \
        sd=74n sa=90n sb=90n ploda1=16n ploda2=0 ploda3=0 plodb1=16n \
        plodb2=0 plodb3=0 nf_flag=1 smbt=1M smbb=1M dinsaflag=0 ppitch=0 \
        spot=103n spob=103n spotl1=103n spobl1=103n spotl2=103n \
        spobl2=103n spotr1=103n spobr1=103n spotr2=103n spobr2=103n
U115 (VDLY CODE115 VDLY VSS) nch_svt_mac l=16n nfin=2 w=58n multi=1 nf=8 \
        sd=74n sa=90n sb=90n ploda1=16n ploda2=0 ploda3=0 plodb1=16n \
        plodb2=0 plodb3=0 nf_flag=1 smbt=1M smbb=1M dinsaflag=0 ppitch=0 \
        spot=103n spob=103n spotl1=103n spobl1=103n spotl2=103n \
        spobl2=103n spotr1=103n spobr1=103n spotr2=103n spobr2=103n
U114 (VDLY CODE114 VDLY VSS) nch_svt_mac l=16n nfin=2 w=58n multi=1 nf=8 \
        sd=74n sa=90n sb=90n ploda1=16n ploda2=0 ploda3=0 plodb1=16n \
        plodb2=0 plodb3=0 nf_flag=1 smbt=1M smbb=1M dinsaflag=0 ppitch=0 \
        spot=103n spob=103n spotl1=103n spobl1=103n spotl2=103n \
        spobl2=103n spotr1=103n spobr1=103n spotr2=103n spobr2=103n
U113 (VDLY CODE113 VDLY VSS) nch_svt_mac l=16n nfin=2 w=58n multi=1 nf=8 \
        sd=74n sa=90n sb=90n ploda1=16n ploda2=0 ploda3=0 plodb1=16n \
        plodb2=0 plodb3=0 nf_flag=1 smbt=1M smbb=1M dinsaflag=0 ppitch=0 \
        spot=103n spob=103n spotl1=103n spobl1=103n spotl2=103n \
        spobl2=103n spotr1=103n spobr1=103n spotr2=103n spobr2=103n
U112 (VDLY CODE112 VDLY VSS) nch_svt_mac l=16n nfin=2 w=58n multi=1 nf=8 \
        sd=74n sa=90n sb=90n ploda1=16n ploda2=0 ploda3=0 plodb1=16n \
        plodb2=0 plodb3=0 nf_flag=1 smbt=1M smbb=1M dinsaflag=0 ppitch=0 \
        spot=103n spob=103n spotl1=103n spobl1=103n spotl2=103n \
        spobl2=103n spotr1=103n spobr1=103n spotr2=103n spobr2=103n
U111 (VDLY CODE111 VDLY VSS) nch_svt_mac l=16n nfin=2 w=58n multi=1 nf=8 \
        sd=74n sa=90n sb=90n ploda1=16n ploda2=0 ploda3=0 plodb1=16n \
        plodb2=0 plodb3=0 nf_flag=1 smbt=1M smbb=1M dinsaflag=0 ppitch=0 \
        spot=103n spob=103n spotl1=103n spobl1=103n spotl2=103n \
        spobl2=103n spotr1=103n spobr1=103n spotr2=103n spobr2=103n
U110 (VDLY CODE110 VDLY VSS) nch_svt_mac l=16n nfin=2 w=58n multi=1 nf=8 \
        sd=74n sa=90n sb=90n ploda1=16n ploda2=0 ploda3=0 plodb1=16n \
        plodb2=0 plodb3=0 nf_flag=1 smbt=1M smbb=1M dinsaflag=0 ppitch=0 \
        spot=103n spob=103n spotl1=103n spobl1=103n spotl2=103n \
        spobl2=103n spotr1=103n spobr1=103n spotr2=103n spobr2=103n
U109 (VDLY CODE109 VDLY VSS) nch_svt_mac l=16n nfin=2 w=58n multi=1 nf=8 \
        sd=74n sa=90n sb=90n ploda1=16n ploda2=0 ploda3=0 plodb1=16n \
        plodb2=0 plodb3=0 nf_flag=1 smbt=1M smbb=1M dinsaflag=0 ppitch=0 \
        spot=103n spob=103n spotl1=103n spobl1=103n spotl2=103n \
        spobl2=103n spotr1=103n spobr1=103n spotr2=103n spobr2=103n
U108 (VDLY CODE108 VDLY VSS) nch_svt_mac l=16n nfin=2 w=58n multi=1 nf=8 \
        sd=74n sa=90n sb=90n ploda1=16n ploda2=0 ploda3=0 plodb1=16n \
        plodb2=0 plodb3=0 nf_flag=1 smbt=1M smbb=1M dinsaflag=0 ppitch=0 \
        spot=103n spob=103n spotl1=103n spobl1=103n spotl2=103n \
        spobl2=103n spotr1=103n spobr1=103n spotr2=103n spobr2=103n
U107 (VDLY CODE107 VDLY VSS) nch_svt_mac l=16n nfin=2 w=58n multi=1 nf=8 \
        sd=74n sa=90n sb=90n ploda1=16n ploda2=0 ploda3=0 plodb1=16n \
        plodb2=0 plodb3=0 nf_flag=1 smbt=1M smbb=1M dinsaflag=0 ppitch=0 \
        spot=103n spob=103n spotl1=103n spobl1=103n spotl2=103n \
        spobl2=103n spotr1=103n spobr1=103n spotr2=103n spobr2=103n
U106 (VDLY CODE106 VDLY VSS) nch_svt_mac l=16n nfin=2 w=58n multi=1 nf=8 \
        sd=74n sa=90n sb=90n ploda1=16n ploda2=0 ploda3=0 plodb1=16n \
        plodb2=0 plodb3=0 nf_flag=1 smbt=1M smbb=1M dinsaflag=0 ppitch=0 \
        spot=103n spob=103n spotl1=103n spobl1=103n spotl2=103n \
        spobl2=103n spotr1=103n spobr1=103n spotr2=103n spobr2=103n
U105 (VDLY CODE105 VDLY VSS) nch_svt_mac l=16n nfin=2 w=58n multi=1 nf=8 \
        sd=74n sa=90n sb=90n ploda1=16n ploda2=0 ploda3=0 plodb1=16n \
        plodb2=0 plodb3=0 nf_flag=1 smbt=1M smbb=1M dinsaflag=0 ppitch=0 \
        spot=103n spob=103n spotl1=103n spobl1=103n spotl2=103n \
        spobl2=103n spotr1=103n spobr1=103n spotr2=103n spobr2=103n
U104 (VDLY CODE104 VDLY VSS) nch_svt_mac l=16n nfin=2 w=58n multi=1 nf=8 \
        sd=74n sa=90n sb=90n ploda1=16n ploda2=0 ploda3=0 plodb1=16n \
        plodb2=0 plodb3=0 nf_flag=1 smbt=1M smbb=1M dinsaflag=0 ppitch=0 \
        spot=103n spob=103n spotl1=103n spobl1=103n spotl2=103n \
        spobl2=103n spotr1=103n spobr1=103n spotr2=103n spobr2=103n
U103 (VDLY CODE103 VDLY VSS) nch_svt_mac l=16n nfin=2 w=58n multi=1 nf=8 \
        sd=74n sa=90n sb=90n ploda1=16n ploda2=0 ploda3=0 plodb1=16n \
        plodb2=0 plodb3=0 nf_flag=1 smbt=1M smbb=1M dinsaflag=0 ppitch=0 \
        spot=103n spob=103n spotl1=103n spobl1=103n spotl2=103n \
        spobl2=103n spotr1=103n spobr1=103n spotr2=103n spobr2=103n
U102 (VDLY CODE102 VDLY VSS) nch_svt_mac l=16n nfin=2 w=58n multi=1 nf=8 \
        sd=74n sa=90n sb=90n ploda1=16n ploda2=0 ploda3=0 plodb1=16n \
        plodb2=0 plodb3=0 nf_flag=1 smbt=1M smbb=1M dinsaflag=0 ppitch=0 \
        spot=103n spob=103n spotl1=103n spobl1=103n spotl2=103n \
        spobl2=103n spotr1=103n spobr1=103n spotr2=103n spobr2=103n
U101 (VDLY CODE101 VDLY VSS) nch_svt_mac l=16n nfin=2 w=58n multi=1 nf=8 \
        sd=74n sa=90n sb=90n ploda1=16n ploda2=0 ploda3=0 plodb1=16n \
        plodb2=0 plodb3=0 nf_flag=1 smbt=1M smbb=1M dinsaflag=0 ppitch=0 \
        spot=103n spob=103n spotl1=103n spobl1=103n spotl2=103n \
        spobl2=103n spotr1=103n spobr1=103n spotr2=103n spobr2=103n
U100 (VDLY CODE100 VDLY VSS) nch_svt_mac l=16n nfin=2 w=58n multi=1 nf=8 \
        sd=74n sa=90n sb=90n ploda1=16n ploda2=0 ploda3=0 plodb1=16n \
        plodb2=0 plodb3=0 nf_flag=1 smbt=1M smbb=1M dinsaflag=0 ppitch=0 \
        spot=103n spob=103n spotl1=103n spobl1=103n spotl2=103n \
        spobl2=103n spotr1=103n spobr1=103n spotr2=103n spobr2=103n
U99 (VDLY CODE99 VDLY VSS) nch_svt_mac l=16n nfin=2 w=58n multi=1 nf=8 \
        sd=74n sa=90n sb=90n ploda1=16n ploda2=0 ploda3=0 plodb1=16n \
        plodb2=0 plodb3=0 nf_flag=1 smbt=1M smbb=1M dinsaflag=0 ppitch=0 \
        spot=103n spob=103n spotl1=103n spobl1=103n spotl2=103n \
        spobl2=103n spotr1=103n spobr1=103n spotr2=103n spobr2=103n
U98 (VDLY CODE98 VDLY VSS) nch_svt_mac l=16n nfin=2 w=58n multi=1 nf=8 \
        sd=74n sa=90n sb=90n ploda1=16n ploda2=0 ploda3=0 plodb1=16n \
        plodb2=0 plodb3=0 nf_flag=1 smbt=1M smbb=1M dinsaflag=0 ppitch=0 \
        spot=103n spob=103n spotl1=103n spobl1=103n spotl2=103n \
        spobl2=103n spotr1=103n spobr1=103n spotr2=103n spobr2=103n
U97 (VDLY CODE97 VDLY VSS) nch_svt_mac l=16n nfin=2 w=58n multi=1 nf=8 \
        sd=74n sa=90n sb=90n ploda1=16n ploda2=0 ploda3=0 plodb1=16n \
        plodb2=0 plodb3=0 nf_flag=1 smbt=1M smbb=1M dinsaflag=0 ppitch=0 \
        spot=103n spob=103n spotl1=103n spobl1=103n spotl2=103n \
        spobl2=103n spotr1=103n spobr1=103n spotr2=103n spobr2=103n
U96 (VDLY CODE96 VDLY VSS) nch_svt_mac l=16n nfin=2 w=58n multi=1 nf=8 \
        sd=74n sa=90n sb=90n ploda1=16n ploda2=0 ploda3=0 plodb1=16n \
        plodb2=0 plodb3=0 nf_flag=1 smbt=1M smbb=1M dinsaflag=0 ppitch=0 \
        spot=103n spob=103n spotl1=103n spobl1=103n spotl2=103n \
        spobl2=103n spotr1=103n spobr1=103n spotr2=103n spobr2=103n
U95 (VDLY CODE95 VDLY VSS) nch_svt_mac l=16n nfin=2 w=58n multi=1 nf=8 \
        sd=74n sa=90n sb=90n ploda1=16n ploda2=0 ploda3=0 plodb1=16n \
        plodb2=0 plodb3=0 nf_flag=1 smbt=1M smbb=1M dinsaflag=0 ppitch=0 \
        spot=103n spob=103n spotl1=103n spobl1=103n spotl2=103n \
        spobl2=103n spotr1=103n spobr1=103n spotr2=103n spobr2=103n
U94 (VDLY CODE94 VDLY VSS) nch_svt_mac l=16n nfin=2 w=58n multi=1 nf=8 \
        sd=74n sa=90n sb=90n ploda1=16n ploda2=0 ploda3=0 plodb1=16n \
        plodb2=0 plodb3=0 nf_flag=1 smbt=1M smbb=1M dinsaflag=0 ppitch=0 \
        spot=103n spob=103n spotl1=103n spobl1=103n spotl2=103n \
        spobl2=103n spotr1=103n spobr1=103n spotr2=103n spobr2=103n
U93 (VDLY CODE93 VDLY VSS) nch_svt_mac l=16n nfin=2 w=58n multi=1 nf=8 \
        sd=74n sa=90n sb=90n ploda1=16n ploda2=0 ploda3=0 plodb1=16n \
        plodb2=0 plodb3=0 nf_flag=1 smbt=1M smbb=1M dinsaflag=0 ppitch=0 \
        spot=103n spob=103n spotl1=103n spobl1=103n spotl2=103n \
        spobl2=103n spotr1=103n spobr1=103n spotr2=103n spobr2=103n
U92 (VDLY CODE92 VDLY VSS) nch_svt_mac l=16n nfin=2 w=58n multi=1 nf=8 \
        sd=74n sa=90n sb=90n ploda1=16n ploda2=0 ploda3=0 plodb1=16n \
        plodb2=0 plodb3=0 nf_flag=1 smbt=1M smbb=1M dinsaflag=0 ppitch=0 \
        spot=103n spob=103n spotl1=103n spobl1=103n spotl2=103n \
        spobl2=103n spotr1=103n spobr1=103n spotr2=103n spobr2=103n
U91 (VDLY CODE91 VDLY VSS) nch_svt_mac l=16n nfin=2 w=58n multi=1 nf=8 \
        sd=74n sa=90n sb=90n ploda1=16n ploda2=0 ploda3=0 plodb1=16n \
        plodb2=0 plodb3=0 nf_flag=1 smbt=1M smbb=1M dinsaflag=0 ppitch=0 \
        spot=103n spob=103n spotl1=103n spobl1=103n spotl2=103n \
        spobl2=103n spotr1=103n spobr1=103n spotr2=103n spobr2=103n
U90 (VDLY CODE90 VDLY VSS) nch_svt_mac l=16n nfin=2 w=58n multi=1 nf=8 \
        sd=74n sa=90n sb=90n ploda1=16n ploda2=0 ploda3=0 plodb1=16n \
        plodb2=0 plodb3=0 nf_flag=1 smbt=1M smbb=1M dinsaflag=0 ppitch=0 \
        spot=103n spob=103n spotl1=103n spobl1=103n spotl2=103n \
        spobl2=103n spotr1=103n spobr1=103n spotr2=103n spobr2=103n
U89 (VDLY CODE89 VDLY VSS) nch_svt_mac l=16n nfin=2 w=58n multi=1 nf=8 \
        sd=74n sa=90n sb=90n ploda1=16n ploda2=0 ploda3=0 plodb1=16n \
        plodb2=0 plodb3=0 nf_flag=1 smbt=1M smbb=1M dinsaflag=0 ppitch=0 \
        spot=103n spob=103n spotl1=103n spobl1=103n spotl2=103n \
        spobl2=103n spotr1=103n spobr1=103n spotr2=103n spobr2=103n
U88 (VDLY CODE88 VDLY VSS) nch_svt_mac l=16n nfin=2 w=58n multi=1 nf=8 \
        sd=74n sa=90n sb=90n ploda1=16n ploda2=0 ploda3=0 plodb1=16n \
        plodb2=0 plodb3=0 nf_flag=1 smbt=1M smbb=1M dinsaflag=0 ppitch=0 \
        spot=103n spob=103n spotl1=103n spobl1=103n spotl2=103n \
        spobl2=103n spotr1=103n spobr1=103n spotr2=103n spobr2=103n
U87 (VDLY CODE87 VDLY VSS) nch_svt_mac l=16n nfin=2 w=58n multi=1 nf=8 \
        sd=74n sa=90n sb=90n ploda1=16n ploda2=0 ploda3=0 plodb1=16n \
        plodb2=0 plodb3=0 nf_flag=1 smbt=1M smbb=1M dinsaflag=0 ppitch=0 \
        spot=103n spob=103n spotl1=103n spobl1=103n spotl2=103n \
        spobl2=103n spotr1=103n spobr1=103n spotr2=103n spobr2=103n
U86 (VDLY CODE86 VDLY VSS) nch_svt_mac l=16n nfin=2 w=58n multi=1 nf=8 \
        sd=74n sa=90n sb=90n ploda1=16n ploda2=0 ploda3=0 plodb1=16n \
        plodb2=0 plodb3=0 nf_flag=1 smbt=1M smbb=1M dinsaflag=0 ppitch=0 \
        spot=103n spob=103n spotl1=103n spobl1=103n spotl2=103n \
        spobl2=103n spotr1=103n spobr1=103n spotr2=103n spobr2=103n
U85 (VDLY CODE85 VDLY VSS) nch_svt_mac l=16n nfin=2 w=58n multi=1 nf=8 \
        sd=74n sa=90n sb=90n ploda1=16n ploda2=0 ploda3=0 plodb1=16n \
        plodb2=0 plodb3=0 nf_flag=1 smbt=1M smbb=1M dinsaflag=0 ppitch=0 \
        spot=103n spob=103n spotl1=103n spobl1=103n spotl2=103n \
        spobl2=103n spotr1=103n spobr1=103n spotr2=103n spobr2=103n
U84 (VDLY CODE84 VDLY VSS) nch_svt_mac l=16n nfin=2 w=58n multi=1 nf=8 \
        sd=74n sa=90n sb=90n ploda1=16n ploda2=0 ploda3=0 plodb1=16n \
        plodb2=0 plodb3=0 nf_flag=1 smbt=1M smbb=1M dinsaflag=0 ppitch=0 \
        spot=103n spob=103n spotl1=103n spobl1=103n spotl2=103n \
        spobl2=103n spotr1=103n spobr1=103n spotr2=103n spobr2=103n
U83 (VDLY CODE83 VDLY VSS) nch_svt_mac l=16n nfin=2 w=58n multi=1 nf=8 \
        sd=74n sa=90n sb=90n ploda1=16n ploda2=0 ploda3=0 plodb1=16n \
        plodb2=0 plodb3=0 nf_flag=1 smbt=1M smbb=1M dinsaflag=0 ppitch=0 \
        spot=103n spob=103n spotl1=103n spobl1=103n spotl2=103n \
        spobl2=103n spotr1=103n spobr1=103n spotr2=103n spobr2=103n
U82 (VDLY CODE82 VDLY VSS) nch_svt_mac l=16n nfin=2 w=58n multi=1 nf=8 \
        sd=74n sa=90n sb=90n ploda1=16n ploda2=0 ploda3=0 plodb1=16n \
        plodb2=0 plodb3=0 nf_flag=1 smbt=1M smbb=1M dinsaflag=0 ppitch=0 \
        spot=103n spob=103n spotl1=103n spobl1=103n spotl2=103n \
        spobl2=103n spotr1=103n spobr1=103n spotr2=103n spobr2=103n
U81 (VDLY CODE81 VDLY VSS) nch_svt_mac l=16n nfin=2 w=58n multi=1 nf=8 \
        sd=74n sa=90n sb=90n ploda1=16n ploda2=0 ploda3=0 plodb1=16n \
        plodb2=0 plodb3=0 nf_flag=1 smbt=1M smbb=1M dinsaflag=0 ppitch=0 \
        spot=103n spob=103n spotl1=103n spobl1=103n spotl2=103n \
        spobl2=103n spotr1=103n spobr1=103n spotr2=103n spobr2=103n
U80 (VDLY CODE80 VDLY VSS) nch_svt_mac l=16n nfin=2 w=58n multi=1 nf=8 \
        sd=74n sa=90n sb=90n ploda1=16n ploda2=0 ploda3=0 plodb1=16n \
        plodb2=0 plodb3=0 nf_flag=1 smbt=1M smbb=1M dinsaflag=0 ppitch=0 \
        spot=103n spob=103n spotl1=103n spobl1=103n spotl2=103n \
        spobl2=103n spotr1=103n spobr1=103n spotr2=103n spobr2=103n
U79 (VDLY CODE79 VDLY VSS) nch_svt_mac l=16n nfin=2 w=58n multi=1 nf=8 \
        sd=74n sa=90n sb=90n ploda1=16n ploda2=0 ploda3=0 plodb1=16n \
        plodb2=0 plodb3=0 nf_flag=1 smbt=1M smbb=1M dinsaflag=0 ppitch=0 \
        spot=103n spob=103n spotl1=103n spobl1=103n spotl2=103n \
        spobl2=103n spotr1=103n spobr1=103n spotr2=103n spobr2=103n
U78 (VDLY CODE78 VDLY VSS) nch_svt_mac l=16n nfin=2 w=58n multi=1 nf=8 \
        sd=74n sa=90n sb=90n ploda1=16n ploda2=0 ploda3=0 plodb1=16n \
        plodb2=0 plodb3=0 nf_flag=1 smbt=1M smbb=1M dinsaflag=0 ppitch=0 \
        spot=103n spob=103n spotl1=103n spobl1=103n spotl2=103n \
        spobl2=103n spotr1=103n spobr1=103n spotr2=103n spobr2=103n
U77 (VDLY CODE77 VDLY VSS) nch_svt_mac l=16n nfin=2 w=58n multi=1 nf=8 \
        sd=74n sa=90n sb=90n ploda1=16n ploda2=0 ploda3=0 plodb1=16n \
        plodb2=0 plodb3=0 nf_flag=1 smbt=1M smbb=1M dinsaflag=0 ppitch=0 \
        spot=103n spob=103n spotl1=103n spobl1=103n spotl2=103n \
        spobl2=103n spotr1=103n spobr1=103n spotr2=103n spobr2=103n
U76 (VDLY CODE76 VDLY VSS) nch_svt_mac l=16n nfin=2 w=58n multi=1 nf=8 \
        sd=74n sa=90n sb=90n ploda1=16n ploda2=0 ploda3=0 plodb1=16n \
        plodb2=0 plodb3=0 nf_flag=1 smbt=1M smbb=1M dinsaflag=0 ppitch=0 \
        spot=103n spob=103n spotl1=103n spobl1=103n spotl2=103n \
        spobl2=103n spotr1=103n spobr1=103n spotr2=103n spobr2=103n
U75 (VDLY CODE75 VDLY VSS) nch_svt_mac l=16n nfin=2 w=58n multi=1 nf=8 \
        sd=74n sa=90n sb=90n ploda1=16n ploda2=0 ploda3=0 plodb1=16n \
        plodb2=0 plodb3=0 nf_flag=1 smbt=1M smbb=1M dinsaflag=0 ppitch=0 \
        spot=103n spob=103n spotl1=103n spobl1=103n spotl2=103n \
        spobl2=103n spotr1=103n spobr1=103n spotr2=103n spobr2=103n
U74 (VDLY CODE74 VDLY VSS) nch_svt_mac l=16n nfin=2 w=58n multi=1 nf=8 \
        sd=74n sa=90n sb=90n ploda1=16n ploda2=0 ploda3=0 plodb1=16n \
        plodb2=0 plodb3=0 nf_flag=1 smbt=1M smbb=1M dinsaflag=0 ppitch=0 \
        spot=103n spob=103n spotl1=103n spobl1=103n spotl2=103n \
        spobl2=103n spotr1=103n spobr1=103n spotr2=103n spobr2=103n
U73 (VDLY CODE73 VDLY VSS) nch_svt_mac l=16n nfin=2 w=58n multi=1 nf=8 \
        sd=74n sa=90n sb=90n ploda1=16n ploda2=0 ploda3=0 plodb1=16n \
        plodb2=0 plodb3=0 nf_flag=1 smbt=1M smbb=1M dinsaflag=0 ppitch=0 \
        spot=103n spob=103n spotl1=103n spobl1=103n spotl2=103n \
        spobl2=103n spotr1=103n spobr1=103n spotr2=103n spobr2=103n
U72 (VDLY CODE72 VDLY VSS) nch_svt_mac l=16n nfin=2 w=58n multi=1 nf=8 \
        sd=74n sa=90n sb=90n ploda1=16n ploda2=0 ploda3=0 plodb1=16n \
        plodb2=0 plodb3=0 nf_flag=1 smbt=1M smbb=1M dinsaflag=0 ppitch=0 \
        spot=103n spob=103n spotl1=103n spobl1=103n spotl2=103n \
        spobl2=103n spotr1=103n spobr1=103n spotr2=103n spobr2=103n
U71 (VDLY CODE71 VDLY VSS) nch_svt_mac l=16n nfin=2 w=58n multi=1 nf=8 \
        sd=74n sa=90n sb=90n ploda1=16n ploda2=0 ploda3=0 plodb1=16n \
        plodb2=0 plodb3=0 nf_flag=1 smbt=1M smbb=1M dinsaflag=0 ppitch=0 \
        spot=103n spob=103n spotl1=103n spobl1=103n spotl2=103n \
        spobl2=103n spotr1=103n spobr1=103n spotr2=103n spobr2=103n
U70 (VDLY CODE70 VDLY VSS) nch_svt_mac l=16n nfin=2 w=58n multi=1 nf=8 \
        sd=74n sa=90n sb=90n ploda1=16n ploda2=0 ploda3=0 plodb1=16n \
        plodb2=0 plodb3=0 nf_flag=1 smbt=1M smbb=1M dinsaflag=0 ppitch=0 \
        spot=103n spob=103n spotl1=103n spobl1=103n spotl2=103n \
        spobl2=103n spotr1=103n spobr1=103n spotr2=103n spobr2=103n
U69 (VDLY CODE69 VDLY VSS) nch_svt_mac l=16n nfin=2 w=58n multi=1 nf=8 \
        sd=74n sa=90n sb=90n ploda1=16n ploda2=0 ploda3=0 plodb1=16n \
        plodb2=0 plodb3=0 nf_flag=1 smbt=1M smbb=1M dinsaflag=0 ppitch=0 \
        spot=103n spob=103n spotl1=103n spobl1=103n spotl2=103n \
        spobl2=103n spotr1=103n spobr1=103n spotr2=103n spobr2=103n
U68 (VDLY CODE68 VDLY VSS) nch_svt_mac l=16n nfin=2 w=58n multi=1 nf=8 \
        sd=74n sa=90n sb=90n ploda1=16n ploda2=0 ploda3=0 plodb1=16n \
        plodb2=0 plodb3=0 nf_flag=1 smbt=1M smbb=1M dinsaflag=0 ppitch=0 \
        spot=103n spob=103n spotl1=103n spobl1=103n spotl2=103n \
        spobl2=103n spotr1=103n spobr1=103n spotr2=103n spobr2=103n
U67 (VDLY CODE67 VDLY VSS) nch_svt_mac l=16n nfin=2 w=58n multi=1 nf=8 \
        sd=74n sa=90n sb=90n ploda1=16n ploda2=0 ploda3=0 plodb1=16n \
        plodb2=0 plodb3=0 nf_flag=1 smbt=1M smbb=1M dinsaflag=0 ppitch=0 \
        spot=103n spob=103n spotl1=103n spobl1=103n spotl2=103n \
        spobl2=103n spotr1=103n spobr1=103n spotr2=103n spobr2=103n
U66 (VDLY CODE66 VDLY VSS) nch_svt_mac l=16n nfin=2 w=58n multi=1 nf=8 \
        sd=74n sa=90n sb=90n ploda1=16n ploda2=0 ploda3=0 plodb1=16n \
        plodb2=0 plodb3=0 nf_flag=1 smbt=1M smbb=1M dinsaflag=0 ppitch=0 \
        spot=103n spob=103n spotl1=103n spobl1=103n spotl2=103n \
        spobl2=103n spotr1=103n spobr1=103n spotr2=103n spobr2=103n
U65 (VDLY CODE65 VDLY VSS) nch_svt_mac l=16n nfin=2 w=58n multi=1 nf=8 \
        sd=74n sa=90n sb=90n ploda1=16n ploda2=0 ploda3=0 plodb1=16n \
        plodb2=0 plodb3=0 nf_flag=1 smbt=1M smbb=1M dinsaflag=0 ppitch=0 \
        spot=103n spob=103n spotl1=103n spobl1=103n spotl2=103n \
        spobl2=103n spotr1=103n spobr1=103n spotr2=103n spobr2=103n
U64 (VDLY CODE64 VDLY VSS) nch_svt_mac l=16n nfin=2 w=58n multi=1 nf=8 \
        sd=74n sa=90n sb=90n ploda1=16n ploda2=0 ploda3=0 plodb1=16n \
        plodb2=0 plodb3=0 nf_flag=1 smbt=1M smbb=1M dinsaflag=0 ppitch=0 \
        spot=103n spob=103n spotl1=103n spobl1=103n spotl2=103n \
        spobl2=103n spotr1=103n spobr1=103n spotr2=103n spobr2=103n
U63 (VDLY CODE63 VDLY VSS) nch_svt_mac l=16n nfin=2 w=58n multi=1 nf=8 \
        sd=74n sa=90n sb=90n ploda1=16n ploda2=0 ploda3=0 plodb1=16n \
        plodb2=0 plodb3=0 nf_flag=1 smbt=1M smbb=1M dinsaflag=0 ppitch=0 \
        spot=103n spob=103n spotl1=103n spobl1=103n spotl2=103n \
        spobl2=103n spotr1=103n spobr1=103n spotr2=103n spobr2=103n
U62 (VDLY CODE62 VDLY VSS) nch_svt_mac l=16n nfin=2 w=58n multi=1 nf=8 \
        sd=74n sa=90n sb=90n ploda1=16n ploda2=0 ploda3=0 plodb1=16n \
        plodb2=0 plodb3=0 nf_flag=1 smbt=1M smbb=1M dinsaflag=0 ppitch=0 \
        spot=103n spob=103n spotl1=103n spobl1=103n spotl2=103n \
        spobl2=103n spotr1=103n spobr1=103n spotr2=103n spobr2=103n
U61 (VDLY CODE61 VDLY VSS) nch_svt_mac l=16n nfin=2 w=58n multi=1 nf=8 \
        sd=74n sa=90n sb=90n ploda1=16n ploda2=0 ploda3=0 plodb1=16n \
        plodb2=0 plodb3=0 nf_flag=1 smbt=1M smbb=1M dinsaflag=0 ppitch=0 \
        spot=103n spob=103n spotl1=103n spobl1=103n spotl2=103n \
        spobl2=103n spotr1=103n spobr1=103n spotr2=103n spobr2=103n
U60 (VDLY CODE60 VDLY VSS) nch_svt_mac l=16n nfin=2 w=58n multi=1 nf=8 \
        sd=74n sa=90n sb=90n ploda1=16n ploda2=0 ploda3=0 plodb1=16n \
        plodb2=0 plodb3=0 nf_flag=1 smbt=1M smbb=1M dinsaflag=0 ppitch=0 \
        spot=103n spob=103n spotl1=103n spobl1=103n spotl2=103n \
        spobl2=103n spotr1=103n spobr1=103n spotr2=103n spobr2=103n
U59 (VDLY CODE59 VDLY VSS) nch_svt_mac l=16n nfin=2 w=58n multi=1 nf=8 \
        sd=74n sa=90n sb=90n ploda1=16n ploda2=0 ploda3=0 plodb1=16n \
        plodb2=0 plodb3=0 nf_flag=1 smbt=1M smbb=1M dinsaflag=0 ppitch=0 \
        spot=103n spob=103n spotl1=103n spobl1=103n spotl2=103n \
        spobl2=103n spotr1=103n spobr1=103n spotr2=103n spobr2=103n
U58 (VDLY CODE58 VDLY VSS) nch_svt_mac l=16n nfin=2 w=58n multi=1 nf=8 \
        sd=74n sa=90n sb=90n ploda1=16n ploda2=0 ploda3=0 plodb1=16n \
        plodb2=0 plodb3=0 nf_flag=1 smbt=1M smbb=1M dinsaflag=0 ppitch=0 \
        spot=103n spob=103n spotl1=103n spobl1=103n spotl2=103n \
        spobl2=103n spotr1=103n spobr1=103n spotr2=103n spobr2=103n
U57 (VDLY CODE57 VDLY VSS) nch_svt_mac l=16n nfin=2 w=58n multi=1 nf=8 \
        sd=74n sa=90n sb=90n ploda1=16n ploda2=0 ploda3=0 plodb1=16n \
        plodb2=0 plodb3=0 nf_flag=1 smbt=1M smbb=1M dinsaflag=0 ppitch=0 \
        spot=103n spob=103n spotl1=103n spobl1=103n spotl2=103n \
        spobl2=103n spotr1=103n spobr1=103n spotr2=103n spobr2=103n
U56 (VDLY CODE56 VDLY VSS) nch_svt_mac l=16n nfin=2 w=58n multi=1 nf=8 \
        sd=74n sa=90n sb=90n ploda1=16n ploda2=0 ploda3=0 plodb1=16n \
        plodb2=0 plodb3=0 nf_flag=1 smbt=1M smbb=1M dinsaflag=0 ppitch=0 \
        spot=103n spob=103n spotl1=103n spobl1=103n spotl2=103n \
        spobl2=103n spotr1=103n spobr1=103n spotr2=103n spobr2=103n
U55 (VDLY CODE55 VDLY VSS) nch_svt_mac l=16n nfin=2 w=58n multi=1 nf=8 \
        sd=74n sa=90n sb=90n ploda1=16n ploda2=0 ploda3=0 plodb1=16n \
        plodb2=0 plodb3=0 nf_flag=1 smbt=1M smbb=1M dinsaflag=0 ppitch=0 \
        spot=103n spob=103n spotl1=103n spobl1=103n spotl2=103n \
        spobl2=103n spotr1=103n spobr1=103n spotr2=103n spobr2=103n
U54 (VDLY CODE54 VDLY VSS) nch_svt_mac l=16n nfin=2 w=58n multi=1 nf=8 \
        sd=74n sa=90n sb=90n ploda1=16n ploda2=0 ploda3=0 plodb1=16n \
        plodb2=0 plodb3=0 nf_flag=1 smbt=1M smbb=1M dinsaflag=0 ppitch=0 \
        spot=103n spob=103n spotl1=103n spobl1=103n spotl2=103n \
        spobl2=103n spotr1=103n spobr1=103n spotr2=103n spobr2=103n
U53 (VDLY CODE53 VDLY VSS) nch_svt_mac l=16n nfin=2 w=58n multi=1 nf=8 \
        sd=74n sa=90n sb=90n ploda1=16n ploda2=0 ploda3=0 plodb1=16n \
        plodb2=0 plodb3=0 nf_flag=1 smbt=1M smbb=1M dinsaflag=0 ppitch=0 \
        spot=103n spob=103n spotl1=103n spobl1=103n spotl2=103n \
        spobl2=103n spotr1=103n spobr1=103n spotr2=103n spobr2=103n
U52 (VDLY CODE52 VDLY VSS) nch_svt_mac l=16n nfin=2 w=58n multi=1 nf=8 \
        sd=74n sa=90n sb=90n ploda1=16n ploda2=0 ploda3=0 plodb1=16n \
        plodb2=0 plodb3=0 nf_flag=1 smbt=1M smbb=1M dinsaflag=0 ppitch=0 \
        spot=103n spob=103n spotl1=103n spobl1=103n spotl2=103n \
        spobl2=103n spotr1=103n spobr1=103n spotr2=103n spobr2=103n
U51 (VDLY CODE51 VDLY VSS) nch_svt_mac l=16n nfin=2 w=58n multi=1 nf=8 \
        sd=74n sa=90n sb=90n ploda1=16n ploda2=0 ploda3=0 plodb1=16n \
        plodb2=0 plodb3=0 nf_flag=1 smbt=1M smbb=1M dinsaflag=0 ppitch=0 \
        spot=103n spob=103n spotl1=103n spobl1=103n spotl2=103n \
        spobl2=103n spotr1=103n spobr1=103n spotr2=103n spobr2=103n
U50 (VDLY CODE50 VDLY VSS) nch_svt_mac l=16n nfin=2 w=58n multi=1 nf=8 \
        sd=74n sa=90n sb=90n ploda1=16n ploda2=0 ploda3=0 plodb1=16n \
        plodb2=0 plodb3=0 nf_flag=1 smbt=1M smbb=1M dinsaflag=0 ppitch=0 \
        spot=103n spob=103n spotl1=103n spobl1=103n spotl2=103n \
        spobl2=103n spotr1=103n spobr1=103n spotr2=103n spobr2=103n
U49 (VDLY CODE49 VDLY VSS) nch_svt_mac l=16n nfin=2 w=58n multi=1 nf=8 \
        sd=74n sa=90n sb=90n ploda1=16n ploda2=0 ploda3=0 plodb1=16n \
        plodb2=0 plodb3=0 nf_flag=1 smbt=1M smbb=1M dinsaflag=0 ppitch=0 \
        spot=103n spob=103n spotl1=103n spobl1=103n spotl2=103n \
        spobl2=103n spotr1=103n spobr1=103n spotr2=103n spobr2=103n
U48 (VDLY CODE48 VDLY VSS) nch_svt_mac l=16n nfin=2 w=58n multi=1 nf=8 \
        sd=74n sa=90n sb=90n ploda1=16n ploda2=0 ploda3=0 plodb1=16n \
        plodb2=0 plodb3=0 nf_flag=1 smbt=1M smbb=1M dinsaflag=0 ppitch=0 \
        spot=103n spob=103n spotl1=103n spobl1=103n spotl2=103n \
        spobl2=103n spotr1=103n spobr1=103n spotr2=103n spobr2=103n
U47 (VDLY CODE47 VDLY VSS) nch_svt_mac l=16n nfin=2 w=58n multi=1 nf=8 \
        sd=74n sa=90n sb=90n ploda1=16n ploda2=0 ploda3=0 plodb1=16n \
        plodb2=0 plodb3=0 nf_flag=1 smbt=1M smbb=1M dinsaflag=0 ppitch=0 \
        spot=103n spob=103n spotl1=103n spobl1=103n spotl2=103n \
        spobl2=103n spotr1=103n spobr1=103n spotr2=103n spobr2=103n
U46 (VDLY CODE46 VDLY VSS) nch_svt_mac l=16n nfin=2 w=58n multi=1 nf=8 \
        sd=74n sa=90n sb=90n ploda1=16n ploda2=0 ploda3=0 plodb1=16n \
        plodb2=0 plodb3=0 nf_flag=1 smbt=1M smbb=1M dinsaflag=0 ppitch=0 \
        spot=103n spob=103n spotl1=103n spobl1=103n spotl2=103n \
        spobl2=103n spotr1=103n spobr1=103n spotr2=103n spobr2=103n
U45 (VDLY CODE45 VDLY VSS) nch_svt_mac l=16n nfin=2 w=58n multi=1 nf=8 \
        sd=74n sa=90n sb=90n ploda1=16n ploda2=0 ploda3=0 plodb1=16n \
        plodb2=0 plodb3=0 nf_flag=1 smbt=1M smbb=1M dinsaflag=0 ppitch=0 \
        spot=103n spob=103n spotl1=103n spobl1=103n spotl2=103n \
        spobl2=103n spotr1=103n spobr1=103n spotr2=103n spobr2=103n
U44 (VDLY CODE44 VDLY VSS) nch_svt_mac l=16n nfin=2 w=58n multi=1 nf=8 \
        sd=74n sa=90n sb=90n ploda1=16n ploda2=0 ploda3=0 plodb1=16n \
        plodb2=0 plodb3=0 nf_flag=1 smbt=1M smbb=1M dinsaflag=0 ppitch=0 \
        spot=103n spob=103n spotl1=103n spobl1=103n spotl2=103n \
        spobl2=103n spotr1=103n spobr1=103n spotr2=103n spobr2=103n
U43 (VDLY CODE43 VDLY VSS) nch_svt_mac l=16n nfin=2 w=58n multi=1 nf=8 \
        sd=74n sa=90n sb=90n ploda1=16n ploda2=0 ploda3=0 plodb1=16n \
        plodb2=0 plodb3=0 nf_flag=1 smbt=1M smbb=1M dinsaflag=0 ppitch=0 \
        spot=103n spob=103n spotl1=103n spobl1=103n spotl2=103n \
        spobl2=103n spotr1=103n spobr1=103n spotr2=103n spobr2=103n
U42 (VDLY CODE42 VDLY VSS) nch_svt_mac l=16n nfin=2 w=58n multi=1 nf=8 \
        sd=74n sa=90n sb=90n ploda1=16n ploda2=0 ploda3=0 plodb1=16n \
        plodb2=0 plodb3=0 nf_flag=1 smbt=1M smbb=1M dinsaflag=0 ppitch=0 \
        spot=103n spob=103n spotl1=103n spobl1=103n spotl2=103n \
        spobl2=103n spotr1=103n spobr1=103n spotr2=103n spobr2=103n
U41 (VDLY CODE41 VDLY VSS) nch_svt_mac l=16n nfin=2 w=58n multi=1 nf=8 \
        sd=74n sa=90n sb=90n ploda1=16n ploda2=0 ploda3=0 plodb1=16n \
        plodb2=0 plodb3=0 nf_flag=1 smbt=1M smbb=1M dinsaflag=0 ppitch=0 \
        spot=103n spob=103n spotl1=103n spobl1=103n spotl2=103n \
        spobl2=103n spotr1=103n spobr1=103n spotr2=103n spobr2=103n
U40 (VDLY CODE40 VDLY VSS) nch_svt_mac l=16n nfin=2 w=58n multi=1 nf=8 \
        sd=74n sa=90n sb=90n ploda1=16n ploda2=0 ploda3=0 plodb1=16n \
        plodb2=0 plodb3=0 nf_flag=1 smbt=1M smbb=1M dinsaflag=0 ppitch=0 \
        spot=103n spob=103n spotl1=103n spobl1=103n spotl2=103n \
        spobl2=103n spotr1=103n spobr1=103n spotr2=103n spobr2=103n
U39 (VDLY CODE39 VDLY VSS) nch_svt_mac l=16n nfin=2 w=58n multi=1 nf=8 \
        sd=74n sa=90n sb=90n ploda1=16n ploda2=0 ploda3=0 plodb1=16n \
        plodb2=0 plodb3=0 nf_flag=1 smbt=1M smbb=1M dinsaflag=0 ppitch=0 \
        spot=103n spob=103n spotl1=103n spobl1=103n spotl2=103n \
        spobl2=103n spotr1=103n spobr1=103n spotr2=103n spobr2=103n
U38 (VDLY CODE38 VDLY VSS) nch_svt_mac l=16n nfin=2 w=58n multi=1 nf=8 \
        sd=74n sa=90n sb=90n ploda1=16n ploda2=0 ploda3=0 plodb1=16n \
        plodb2=0 plodb3=0 nf_flag=1 smbt=1M smbb=1M dinsaflag=0 ppitch=0 \
        spot=103n spob=103n spotl1=103n spobl1=103n spotl2=103n \
        spobl2=103n spotr1=103n spobr1=103n spotr2=103n spobr2=103n
U37 (VDLY CODE37 VDLY VSS) nch_svt_mac l=16n nfin=2 w=58n multi=1 nf=8 \
        sd=74n sa=90n sb=90n ploda1=16n ploda2=0 ploda3=0 plodb1=16n \
        plodb2=0 plodb3=0 nf_flag=1 smbt=1M smbb=1M dinsaflag=0 ppitch=0 \
        spot=103n spob=103n spotl1=103n spobl1=103n spotl2=103n \
        spobl2=103n spotr1=103n spobr1=103n spotr2=103n spobr2=103n
U36 (VDLY CODE36 VDLY VSS) nch_svt_mac l=16n nfin=2 w=58n multi=1 nf=8 \
        sd=74n sa=90n sb=90n ploda1=16n ploda2=0 ploda3=0 plodb1=16n \
        plodb2=0 plodb3=0 nf_flag=1 smbt=1M smbb=1M dinsaflag=0 ppitch=0 \
        spot=103n spob=103n spotl1=103n spobl1=103n spotl2=103n \
        spobl2=103n spotr1=103n spobr1=103n spotr2=103n spobr2=103n
U35 (VDLY CODE35 VDLY VSS) nch_svt_mac l=16n nfin=2 w=58n multi=1 nf=8 \
        sd=74n sa=90n sb=90n ploda1=16n ploda2=0 ploda3=0 plodb1=16n \
        plodb2=0 plodb3=0 nf_flag=1 smbt=1M smbb=1M dinsaflag=0 ppitch=0 \
        spot=103n spob=103n spotl1=103n spobl1=103n spotl2=103n \
        spobl2=103n spotr1=103n spobr1=103n spotr2=103n spobr2=103n
U34 (VDLY CODE34 VDLY VSS) nch_svt_mac l=16n nfin=2 w=58n multi=1 nf=8 \
        sd=74n sa=90n sb=90n ploda1=16n ploda2=0 ploda3=0 plodb1=16n \
        plodb2=0 plodb3=0 nf_flag=1 smbt=1M smbb=1M dinsaflag=0 ppitch=0 \
        spot=103n spob=103n spotl1=103n spobl1=103n spotl2=103n \
        spobl2=103n spotr1=103n spobr1=103n spotr2=103n spobr2=103n
U33 (VDLY CODE33 VDLY VSS) nch_svt_mac l=16n nfin=2 w=58n multi=1 nf=8 \
        sd=74n sa=90n sb=90n ploda1=16n ploda2=0 ploda3=0 plodb1=16n \
        plodb2=0 plodb3=0 nf_flag=1 smbt=1M smbb=1M dinsaflag=0 ppitch=0 \
        spot=103n spob=103n spotl1=103n spobl1=103n spotl2=103n \
        spobl2=103n spotr1=103n spobr1=103n spotr2=103n spobr2=103n
U32 (VDLY CODE32 VDLY VSS) nch_svt_mac l=16n nfin=2 w=58n multi=1 nf=8 \
        sd=74n sa=90n sb=90n ploda1=16n ploda2=0 ploda3=0 plodb1=16n \
        plodb2=0 plodb3=0 nf_flag=1 smbt=1M smbb=1M dinsaflag=0 ppitch=0 \
        spot=103n spob=103n spotl1=103n spobl1=103n spotl2=103n \
        spobl2=103n spotr1=103n spobr1=103n spotr2=103n spobr2=103n
U31 (VDLY CODE31 VDLY VSS) nch_svt_mac l=16n nfin=2 w=58n multi=1 nf=8 \
        sd=74n sa=90n sb=90n ploda1=16n ploda2=0 ploda3=0 plodb1=16n \
        plodb2=0 plodb3=0 nf_flag=1 smbt=1M smbb=1M dinsaflag=0 ppitch=0 \
        spot=103n spob=103n spotl1=103n spobl1=103n spotl2=103n \
        spobl2=103n spotr1=103n spobr1=103n spotr2=103n spobr2=103n
U30 (VDLY CODE30 VDLY VSS) nch_svt_mac l=16n nfin=2 w=58n multi=1 nf=8 \
        sd=74n sa=90n sb=90n ploda1=16n ploda2=0 ploda3=0 plodb1=16n \
        plodb2=0 plodb3=0 nf_flag=1 smbt=1M smbb=1M dinsaflag=0 ppitch=0 \
        spot=103n spob=103n spotl1=103n spobl1=103n spotl2=103n \
        spobl2=103n spotr1=103n spobr1=103n spotr2=103n spobr2=103n
U29 (VDLY CODE29 VDLY VSS) nch_svt_mac l=16n nfin=2 w=58n multi=1 nf=8 \
        sd=74n sa=90n sb=90n ploda1=16n ploda2=0 ploda3=0 plodb1=16n \
        plodb2=0 plodb3=0 nf_flag=1 smbt=1M smbb=1M dinsaflag=0 ppitch=0 \
        spot=103n spob=103n spotl1=103n spobl1=103n spotl2=103n \
        spobl2=103n spotr1=103n spobr1=103n spotr2=103n spobr2=103n
U28 (VDLY CODE28 VDLY VSS) nch_svt_mac l=16n nfin=2 w=58n multi=1 nf=8 \
        sd=74n sa=90n sb=90n ploda1=16n ploda2=0 ploda3=0 plodb1=16n \
        plodb2=0 plodb3=0 nf_flag=1 smbt=1M smbb=1M dinsaflag=0 ppitch=0 \
        spot=103n spob=103n spotl1=103n spobl1=103n spotl2=103n \
        spobl2=103n spotr1=103n spobr1=103n spotr2=103n spobr2=103n
U27 (VDLY CODE27 VDLY VSS) nch_svt_mac l=16n nfin=2 w=58n multi=1 nf=8 \
        sd=74n sa=90n sb=90n ploda1=16n ploda2=0 ploda3=0 plodb1=16n \
        plodb2=0 plodb3=0 nf_flag=1 smbt=1M smbb=1M dinsaflag=0 ppitch=0 \
        spot=103n spob=103n spotl1=103n spobl1=103n spotl2=103n \
        spobl2=103n spotr1=103n spobr1=103n spotr2=103n spobr2=103n
U26 (VDLY CODE26 VDLY VSS) nch_svt_mac l=16n nfin=2 w=58n multi=1 nf=8 \
        sd=74n sa=90n sb=90n ploda1=16n ploda2=0 ploda3=0 plodb1=16n \
        plodb2=0 plodb3=0 nf_flag=1 smbt=1M smbb=1M dinsaflag=0 ppitch=0 \
        spot=103n spob=103n spotl1=103n spobl1=103n spotl2=103n \
        spobl2=103n spotr1=103n spobr1=103n spotr2=103n spobr2=103n
U25 (VDLY CODE25 VDLY VSS) nch_svt_mac l=16n nfin=2 w=58n multi=1 nf=8 \
        sd=74n sa=90n sb=90n ploda1=16n ploda2=0 ploda3=0 plodb1=16n \
        plodb2=0 plodb3=0 nf_flag=1 smbt=1M smbb=1M dinsaflag=0 ppitch=0 \
        spot=103n spob=103n spotl1=103n spobl1=103n spotl2=103n \
        spobl2=103n spotr1=103n spobr1=103n spotr2=103n spobr2=103n
U24 (VDLY CODE24 VDLY VSS) nch_svt_mac l=16n nfin=2 w=58n multi=1 nf=8 \
        sd=74n sa=90n sb=90n ploda1=16n ploda2=0 ploda3=0 plodb1=16n \
        plodb2=0 plodb3=0 nf_flag=1 smbt=1M smbb=1M dinsaflag=0 ppitch=0 \
        spot=103n spob=103n spotl1=103n spobl1=103n spotl2=103n \
        spobl2=103n spotr1=103n spobr1=103n spotr2=103n spobr2=103n
U23 (VDLY CODE23 VDLY VSS) nch_svt_mac l=16n nfin=2 w=58n multi=1 nf=8 \
        sd=74n sa=90n sb=90n ploda1=16n ploda2=0 ploda3=0 plodb1=16n \
        plodb2=0 plodb3=0 nf_flag=1 smbt=1M smbb=1M dinsaflag=0 ppitch=0 \
        spot=103n spob=103n spotl1=103n spobl1=103n spotl2=103n \
        spobl2=103n spotr1=103n spobr1=103n spotr2=103n spobr2=103n
U22 (VDLY CODE22 VDLY VSS) nch_svt_mac l=16n nfin=2 w=58n multi=1 nf=8 \
        sd=74n sa=90n sb=90n ploda1=16n ploda2=0 ploda3=0 plodb1=16n \
        plodb2=0 plodb3=0 nf_flag=1 smbt=1M smbb=1M dinsaflag=0 ppitch=0 \
        spot=103n spob=103n spotl1=103n spobl1=103n spotl2=103n \
        spobl2=103n spotr1=103n spobr1=103n spotr2=103n spobr2=103n
U21 (VDLY CODE21 VDLY VSS) nch_svt_mac l=16n nfin=2 w=58n multi=1 nf=8 \
        sd=74n sa=90n sb=90n ploda1=16n ploda2=0 ploda3=0 plodb1=16n \
        plodb2=0 plodb3=0 nf_flag=1 smbt=1M smbb=1M dinsaflag=0 ppitch=0 \
        spot=103n spob=103n spotl1=103n spobl1=103n spotl2=103n \
        spobl2=103n spotr1=103n spobr1=103n spotr2=103n spobr2=103n
U20 (VDLY CODE20 VDLY VSS) nch_svt_mac l=16n nfin=2 w=58n multi=1 nf=8 \
        sd=74n sa=90n sb=90n ploda1=16n ploda2=0 ploda3=0 plodb1=16n \
        plodb2=0 plodb3=0 nf_flag=1 smbt=1M smbb=1M dinsaflag=0 ppitch=0 \
        spot=103n spob=103n spotl1=103n spobl1=103n spotl2=103n \
        spobl2=103n spotr1=103n spobr1=103n spotr2=103n spobr2=103n
U19 (VDLY CODE19 VDLY VSS) nch_svt_mac l=16n nfin=2 w=58n multi=1 nf=8 \
        sd=74n sa=90n sb=90n ploda1=16n ploda2=0 ploda3=0 plodb1=16n \
        plodb2=0 plodb3=0 nf_flag=1 smbt=1M smbb=1M dinsaflag=0 ppitch=0 \
        spot=103n spob=103n spotl1=103n spobl1=103n spotl2=103n \
        spobl2=103n spotr1=103n spobr1=103n spotr2=103n spobr2=103n
U18 (VDLY CODE18 VDLY VSS) nch_svt_mac l=16n nfin=2 w=58n multi=1 nf=8 \
        sd=74n sa=90n sb=90n ploda1=16n ploda2=0 ploda3=0 plodb1=16n \
        plodb2=0 plodb3=0 nf_flag=1 smbt=1M smbb=1M dinsaflag=0 ppitch=0 \
        spot=103n spob=103n spotl1=103n spobl1=103n spotl2=103n \
        spobl2=103n spotr1=103n spobr1=103n spotr2=103n spobr2=103n
U17 (VDLY CODE17 VDLY VSS) nch_svt_mac l=16n nfin=2 w=58n multi=1 nf=8 \
        sd=74n sa=90n sb=90n ploda1=16n ploda2=0 ploda3=0 plodb1=16n \
        plodb2=0 plodb3=0 nf_flag=1 smbt=1M smbb=1M dinsaflag=0 ppitch=0 \
        spot=103n spob=103n spotl1=103n spobl1=103n spotl2=103n \
        spobl2=103n spotr1=103n spobr1=103n spotr2=103n spobr2=103n
U16 (VDLY CODE16 VDLY VSS) nch_svt_mac l=16n nfin=2 w=58n multi=1 nf=8 \
        sd=74n sa=90n sb=90n ploda1=16n ploda2=0 ploda3=0 plodb1=16n \
        plodb2=0 plodb3=0 nf_flag=1 smbt=1M smbb=1M dinsaflag=0 ppitch=0 \
        spot=103n spob=103n spotl1=103n spobl1=103n spotl2=103n \
        spobl2=103n spotr1=103n spobr1=103n spotr2=103n spobr2=103n
U15 (VDLY CODE15 VDLY VSS) nch_svt_mac l=16n nfin=2 w=58n multi=1 nf=8 \
        sd=74n sa=90n sb=90n ploda1=16n ploda2=0 ploda3=0 plodb1=16n \
        plodb2=0 plodb3=0 nf_flag=1 smbt=1M smbb=1M dinsaflag=0 ppitch=0 \
        spot=103n spob=103n spotl1=103n spobl1=103n spotl2=103n \
        spobl2=103n spotr1=103n spobr1=103n spotr2=103n spobr2=103n
U14 (VDLY CODE14 VDLY VSS) nch_svt_mac l=16n nfin=2 w=58n multi=1 nf=8 \
        sd=74n sa=90n sb=90n ploda1=16n ploda2=0 ploda3=0 plodb1=16n \
        plodb2=0 plodb3=0 nf_flag=1 smbt=1M smbb=1M dinsaflag=0 ppitch=0 \
        spot=103n spob=103n spotl1=103n spobl1=103n spotl2=103n \
        spobl2=103n spotr1=103n spobr1=103n spotr2=103n spobr2=103n
U13 (VDLY CODE13 VDLY VSS) nch_svt_mac l=16n nfin=2 w=58n multi=1 nf=8 \
        sd=74n sa=90n sb=90n ploda1=16n ploda2=0 ploda3=0 plodb1=16n \
        plodb2=0 plodb3=0 nf_flag=1 smbt=1M smbb=1M dinsaflag=0 ppitch=0 \
        spot=103n spob=103n spotl1=103n spobl1=103n spotl2=103n \
        spobl2=103n spotr1=103n spobr1=103n spotr2=103n spobr2=103n
U12 (VDLY CODE12 VDLY VSS) nch_svt_mac l=16n nfin=2 w=58n multi=1 nf=8 \
        sd=74n sa=90n sb=90n ploda1=16n ploda2=0 ploda3=0 plodb1=16n \
        plodb2=0 plodb3=0 nf_flag=1 smbt=1M smbb=1M dinsaflag=0 ppitch=0 \
        spot=103n spob=103n spotl1=103n spobl1=103n spotl2=103n \
        spobl2=103n spotr1=103n spobr1=103n spotr2=103n spobr2=103n
U11 (VDLY CODE11 VDLY VSS) nch_svt_mac l=16n nfin=2 w=58n multi=1 nf=8 \
        sd=74n sa=90n sb=90n ploda1=16n ploda2=0 ploda3=0 plodb1=16n \
        plodb2=0 plodb3=0 nf_flag=1 smbt=1M smbb=1M dinsaflag=0 ppitch=0 \
        spot=103n spob=103n spotl1=103n spobl1=103n spotl2=103n \
        spobl2=103n spotr1=103n spobr1=103n spotr2=103n spobr2=103n
U10 (VDLY CODE10 VDLY VSS) nch_svt_mac l=16n nfin=2 w=58n multi=1 nf=8 \
        sd=74n sa=90n sb=90n ploda1=16n ploda2=0 ploda3=0 plodb1=16n \
        plodb2=0 plodb3=0 nf_flag=1 smbt=1M smbb=1M dinsaflag=0 ppitch=0 \
        spot=103n spob=103n spotl1=103n spobl1=103n spotl2=103n \
        spobl2=103n spotr1=103n spobr1=103n spotr2=103n spobr2=103n
U9 (VDLY CODE9 VDLY VSS) nch_svt_mac l=16n nfin=2 w=58n multi=1 nf=8 \
        sd=74n sa=90n sb=90n ploda1=16n ploda2=0 ploda3=0 plodb1=16n \
        plodb2=0 plodb3=0 nf_flag=1 smbt=1M smbb=1M dinsaflag=0 ppitch=0 \
        spot=103n spob=103n spotl1=103n spobl1=103n spotl2=103n \
        spobl2=103n spotr1=103n spobr1=103n spotr2=103n spobr2=103n
U8 (VDLY CODE8 VDLY VSS) nch_svt_mac l=16n nfin=2 w=58n multi=1 nf=8 \
        sd=74n sa=90n sb=90n ploda1=16n ploda2=0 ploda3=0 plodb1=16n \
        plodb2=0 plodb3=0 nf_flag=1 smbt=1M smbb=1M dinsaflag=0 ppitch=0 \
        spot=103n spob=103n spotl1=103n spobl1=103n spotl2=103n \
        spobl2=103n spotr1=103n spobr1=103n spotr2=103n spobr2=103n
U7 (VDLY CODE7 VDLY VSS) nch_svt_mac l=16n nfin=2 w=58n multi=1 nf=8 \
        sd=74n sa=90n sb=90n ploda1=16n ploda2=0 ploda3=0 plodb1=16n \
        plodb2=0 plodb3=0 nf_flag=1 smbt=1M smbb=1M dinsaflag=0 ppitch=0 \
        spot=103n spob=103n spotl1=103n spobl1=103n spotl2=103n \
        spobl2=103n spotr1=103n spobr1=103n spotr2=103n spobr2=103n
U6 (VDLY CODE6 VDLY VSS) nch_svt_mac l=16n nfin=2 w=58n multi=1 nf=8 \
        sd=74n sa=90n sb=90n ploda1=16n ploda2=0 ploda3=0 plodb1=16n \
        plodb2=0 plodb3=0 nf_flag=1 smbt=1M smbb=1M dinsaflag=0 ppitch=0 \
        spot=103n spob=103n spotl1=103n spobl1=103n spotl2=103n \
        spobl2=103n spotr1=103n spobr1=103n spotr2=103n spobr2=103n
U5 (VDLY CODE5 VDLY VSS) nch_svt_mac l=16n nfin=2 w=58n multi=1 nf=8 \
        sd=74n sa=90n sb=90n ploda1=16n ploda2=0 ploda3=0 plodb1=16n \
        plodb2=0 plodb3=0 nf_flag=1 smbt=1M smbb=1M dinsaflag=0 ppitch=0 \
        spot=103n spob=103n spotl1=103n spobl1=103n spotl2=103n \
        spobl2=103n spotr1=103n spobr1=103n spotr2=103n spobr2=103n
U4 (VDLY CODE4 VDLY VSS) nch_svt_mac l=16n nfin=2 w=58n multi=1 nf=8 \
        sd=74n sa=90n sb=90n ploda1=16n ploda2=0 ploda3=0 plodb1=16n \
        plodb2=0 plodb3=0 nf_flag=1 smbt=1M smbb=1M dinsaflag=0 ppitch=0 \
        spot=103n spob=103n spotl1=103n spobl1=103n spotl2=103n \
        spobl2=103n spotr1=103n spobr1=103n spotr2=103n spobr2=103n
U3 (VDLY CODE3 VDLY VSS) nch_svt_mac l=16n nfin=2 w=58n multi=1 nf=8 \
        sd=74n sa=90n sb=90n ploda1=16n ploda2=0 ploda3=0 plodb1=16n \
        plodb2=0 plodb3=0 nf_flag=1 smbt=1M smbb=1M dinsaflag=0 ppitch=0 \
        spot=103n spob=103n spotl1=103n spobl1=103n spotl2=103n \
        spobl2=103n spotr1=103n spobr1=103n spotr2=103n spobr2=103n
U2 (VDLY CODE2 VDLY VSS) nch_svt_mac l=16n nfin=2 w=58n multi=1 nf=8 \
        sd=74n sa=90n sb=90n ploda1=16n ploda2=0 ploda3=0 plodb1=16n \
        plodb2=0 plodb3=0 nf_flag=1 smbt=1M smbb=1M dinsaflag=0 ppitch=0 \
        spot=103n spob=103n spotl1=103n spobl1=103n spotl2=103n \
        spobl2=103n spotr1=103n spobr1=103n spotr2=103n spobr2=103n
U1 (VDLY CODE1 VDLY VSS) nch_svt_mac l=16n nfin=2 w=58n multi=1 nf=8 \
        sd=74n sa=90n sb=90n ploda1=16n ploda2=0 ploda3=0 plodb1=16n \
        plodb2=0 plodb3=0 nf_flag=1 smbt=1M smbb=1M dinsaflag=0 ppitch=0 \
        spot=103n spob=103n spotl1=103n spobl1=103n spotl2=103n \
        spobl2=103n spotr1=103n spobr1=103n spotr2=103n spobr2=103n
U0 (VDLY CODE0 VDLY VSS) nch_svt_mac l=16n nfin=2 w=58n multi=1 nf=8 \
        sd=74n sa=90n sb=90n ploda1=16n ploda2=0 ploda3=0 plodb1=16n \
        plodb2=0 plodb3=0 nf_flag=1 smbt=1M smbb=1M dinsaflag=0 ppitch=0 \
        spot=103n spob=103n spotl1=103n spobl1=103n spotl2=103n \
        spobl2=103n spotr1=103n spobr1=103n spotr2=103n spobr2=103n
MN1 (CK_OUT VDLY VSS VSS) nch_svt_mac l=16n nfin=2 w=58n multi=1 nf=8 \
        sd=74n sa=90n sb=90n ploda1=16n ploda2=0 ploda3=0 plodb1=16n \
        plodb2=0 plodb3=0 nf_flag=1 smbt=1M smbb=1M dinsaflag=0 ppitch=0 \
        spot=103n spob=103n spotl1=103n spobl1=103n spotl2=103n \
        spobl2=103n spotr1=103n spobr1=103n spotr2=103n spobr2=103n
MP1 (CK_OUT VDLY VDD VDD) pch_svt_mac l=16n nfin=2 w=58n multi=1 nf=1 \
        sd=74n sa=90n sb=90n ploda1=16n ploda2=0 ploda3=0 plodb1=16n \
        plodb2=0 plodb3=0 nf_flag=1 smbt=1M smbb=1M dinsaflag=0 ppitch=0 \
        spot=103n spob=103n spotl1=103n spobl1=103n spotl2=103n \
        spobl2=103n spotr1=103n spobr1=103n spotr2=103n spobr2=103n
ends dtc_x

subckt spd_x (VBIAS CK_RST CK_SMP VHOLD VRAMP VDD VSS)

MCS (VRAMP VBIAS VDD VDD) pch_svt_mac l=16n nfin=2 w=58n multi=1 nf=6 \
        sd=74n sa=90n sb=90n ploda1=16n ploda2=0 ploda3=0 plodb1=16n \
        plodb2=0 plodb3=0 nf_flag=1 smbt=1M smbb=1M dinsaflag=0 ppitch=0 \
        spot=103n spob=103n spotl1=103n spobl1=103n spotl2=103n \
        spobl2=103n spotr1=103n spobr1=103n spotr2=103n spobr2=103n
MSMP (VRAMP CK_SMP VHOLD VSS) nch_svt_mac l=16n nfin=2 w=58n multi=1 nf=8 \
        sd=74n sa=90n sb=90n ploda1=16n ploda2=0 ploda3=0 plodb1=16n \
        plodb2=0 plodb3=0 nf_flag=1 smbt=1M smbb=1M dinsaflag=0 ppitch=0 \
        spot=103n spob=103n spotl1=103n spobl1=103n spotl2=103n \
        spobl2=103n spotr1=103n spobr1=103n spotr2=103n spobr2=103n
MRST (VRAMP CK_RST VSS VSS) nch_svt_mac l=16n nfin=2 w=58n multi=1 nf=32 \
        sd=74n sa=90n sb=90n ploda1=16n ploda2=0 ploda3=0 plodb1=16n \
        plodb2=0 plodb3=0 nf_flag=1 smbt=1M smbb=1M dinsaflag=0 ppitch=0 \
        spot=103n spob=103n spotl1=103n spobl1=103n spotl2=103n \
        spobl2=103n spotr1=103n spobr1=103n spotr2=103n spobr2=103n
CH (VHOLD VSS VSS) cfmom_wo_p80 dmflag=0 lr=1u multi=1 mxd_flag=0 nr=12 \
        n_mxa=2 shield=2 spm=3 stm=1 vapmod=2 grflag=1 gdis_t=185n \
        gdis_b=185n gdis_l=102n gdis_r=102n
CR5 (VSS VSS VSS) cfmom_wo_p80 dmflag=0 lr=1u multi=1 mxd_flag=0 nr=12 \
        n_mxa=2 shield=2 spm=3 stm=1 vapmod=2 grflag=1 gdis_t=185n \
        gdis_b=185n gdis_l=102n gdis_r=102n
CR4 (VSS VSS VSS) cfmom_wo_p80 dmflag=0 lr=1u multi=1 mxd_flag=0 nr=12 \
        n_mxa=2 shield=2 spm=3 stm=1 vapmod=2 grflag=1 gdis_t=185n \
        gdis_b=185n gdis_l=102n gdis_r=102n
CR3 (VSS VSS VSS) cfmom_wo_p80 dmflag=0 lr=1u multi=1 mxd_flag=0 nr=12 \
        n_mxa=2 shield=2 spm=3 stm=1 vapmod=2 grflag=1 gdis_t=185n \
        gdis_b=185n gdis_l=102n gdis_r=102n
CR2 (VSS VSS VSS) cfmom_wo_p80 dmflag=0 lr=1u multi=1 mxd_flag=0 nr=12 \
        n_mxa=2 shield=2 spm=3 stm=1 vapmod=2 grflag=1 gdis_t=185n \
        gdis_b=185n gdis_l=102n gdis_r=102n
CR1 (VSS VSS VSS) cfmom_wo_p80 dmflag=0 lr=1u multi=1 mxd_flag=0 nr=12 \
        n_mxa=2 shield=2 spm=3 stm=1 vapmod=2 grflag=1 gdis_t=185n \
        gdis_b=185n gdis_l=102n gdis_r=102n
CR0 (VRAMP VSS VSS) cfmom_wo_p80 dmflag=0 lr=1u multi=1 mxd_flag=0 nr=12 \
        n_mxa=2 shield=2 spm=3 stm=1 vapmod=2 grflag=1 gdis_t=185n \
        gdis_b=185n gdis_l=102n gdis_r=102n
ends spd_x

subckt cmp_x (VINP VINN VBIAS EOUT VDD VSS)

MN3 (EOUT OUTP1 VSS VSS) nch_svt_mac l=16n nfin=2 w=58n multi=1 nf=2 \
        sd=74n sa=90n sb=90n ploda1=16n ploda2=0 ploda3=0 plodb1=16n \
        plodb2=0 plodb3=0 nf_flag=1 smbt=1M smbb=1M dinsaflag=0 ppitch=0 \
        spot=103n spob=103n spotl1=103n spobl1=103n spotl2=103n \
        spobl2=103n spotr1=103n spobr1=103n spotr2=103n spobr2=103n
MN2 (OUTP1 VINP TAILN VSS) nch_svt_mac l=16n nfin=2 w=58n multi=1 nf=2 \
        sd=74n sa=90n sb=90n ploda1=16n ploda2=0 ploda3=0 plodb1=16n \
        plodb2=0 plodb3=0 nf_flag=1 smbt=1M smbb=1M dinsaflag=0 ppitch=0 \
        spot=103n spob=103n spotl1=103n spobl1=103n spotl2=103n \
        spobl2=103n spotr1=103n spobr1=103n spotr2=103n spobr2=103n
MN1 (OUTN1 VINN TAILN VSS) nch_svt_mac l=16n nfin=2 w=58n multi=1 nf=2 \
        sd=74n sa=90n sb=90n ploda1=16n ploda2=0 ploda3=0 plodb1=16n \
        plodb2=0 plodb3=0 nf_flag=1 smbt=1M smbb=1M dinsaflag=0 ppitch=0 \
        spot=103n spob=103n spotl1=103n spobl1=103n spotl2=103n \
        spobl2=103n spotr1=103n spobr1=103n spotr2=103n spobr2=103n
MTAIL (TAILN VBIAS VSS VSS) nch_svt_mac l=16n nfin=2 w=58n multi=1 nf=2 \
        sd=74n sa=90n sb=90n ploda1=16n ploda2=0 ploda3=0 plodb1=16n \
        plodb2=0 plodb3=0 nf_flag=1 smbt=1M smbb=1M dinsaflag=0 ppitch=0 \
        spot=103n spob=103n spotl1=103n spobl1=103n spotl2=103n \
        spobl2=103n spotr1=103n spobr1=103n spotr2=103n spobr2=103n
MP3 (EOUT OUTP1 VDD VDD) pch_svt_mac l=16n nfin=2 w=58n multi=1 nf=2 \
        sd=74n sa=90n sb=90n ploda1=16n ploda2=0 ploda3=0 plodb1=16n \
        plodb2=0 plodb3=0 nf_flag=1 smbt=1M smbb=1M dinsaflag=0 ppitch=0 \
        spot=103n spob=103n spotl1=103n spobl1=103n spotl2=103n \
        spobl2=103n spotr1=103n spobr1=103n spotr2=103n spobr2=103n
MP2 (OUTP1 OUTN1 VDD VDD) pch_svt_mac l=16n nfin=2 w=58n multi=1 nf=2 \
        sd=74n sa=90n sb=90n ploda1=16n ploda2=0 ploda3=0 plodb1=16n \
        plodb2=0 plodb3=0 nf_flag=1 smbt=1M smbb=1M dinsaflag=0 ppitch=0 \
        spot=103n spob=103n spotl1=103n spobl1=103n spotl2=103n \
        spobl2=103n spotr1=103n spobr1=103n spotr2=103n spobr2=103n
MP1 (OUTN1 OUTN1 VDD VDD) pch_svt_mac l=16n nfin=2 w=58n multi=1 nf=2 \
        sd=74n sa=90n sb=90n ploda1=16n ploda2=0 ploda3=0 plodb1=16n \
        plodb2=0 plodb3=0 nf_flag=1 smbt=1M smbb=1M dinsaflag=0 ppitch=0 \
        spot=103n spob=103n spotl1=103n spobl1=103n spotl2=103n \
        spobl2=103n spotr1=103n spobr1=103n spotr2=103n spobr2=103n
ends cmp_x

subckt gm_x (VINP VINN VBIAS IOUT VDD VSS)

MN2 (IOUT VINN TAILN VSS) nch_svt_mac l=16n nfin=2 w=58n multi=1 nf=1 \
        sd=74n sa=90n sb=90n ploda1=16n ploda2=0 ploda3=0 plodb1=16n \
        plodb2=0 plodb3=0 nf_flag=1 smbt=1M smbb=1M dinsaflag=0 ppitch=0 \
        spot=103n spob=103n spotl1=103n spobl1=103n spotl2=103n \
        spobl2=103n spotr1=103n spobr1=103n spotr2=103n spobr2=103n
MN1 (OUTN VINP TAILN VSS) nch_svt_mac l=16n nfin=2 w=58n multi=1 nf=1 \
        sd=74n sa=90n sb=90n ploda1=16n ploda2=0 ploda3=0 plodb1=16n \
        plodb2=0 plodb3=0 nf_flag=1 smbt=1M smbb=1M dinsaflag=0 ppitch=0 \
        spot=103n spob=103n spotl1=103n spobl1=103n spotl2=103n \
        spobl2=103n spotr1=103n spobr1=103n spotr2=103n spobr2=103n
MTAIL (TAILN VBIAS VSS VSS) nch_svt_mac l=16n nfin=2 w=58n multi=1 nf=1 \
        sd=74n sa=90n sb=90n ploda1=16n ploda2=0 ploda3=0 plodb1=16n \
        plodb2=0 plodb3=0 nf_flag=1 smbt=1M smbb=1M dinsaflag=0 ppitch=0 \
        spot=103n spob=103n spotl1=103n spobl1=103n spotl2=103n \
        spobl2=103n spotr1=103n spobr1=103n spotr2=103n spobr2=103n
; v2 fix: GM mirror 1/4.5 - pull-up 8.4nA->1.9nA, symmetric with pull-down
MP2 (IOUT OUTN VDD VDD) pch_svt_mac l=72n nfin=2 w=58n multi=1 nf=1 sd=74n \
        sa=90n sb=90n ploda1=16n ploda2=0 ploda3=0 plodb1=16n plodb2=0 \
        plodb3=0 nf_flag=1 smbt=1M smbb=1M dinsaflag=0 ppitch=0 spot=103n \
        spob=103n spotl1=103n spobl1=103n spotl2=103n spobl2=103n \
        spotr1=103n spobr1=103n spotr2=103n spobr2=103n
MP1 (OUTN OUTN VDD VDD) pch_svt_mac l=16n nfin=2 w=58n multi=1 nf=1 sd=74n \
        sa=90n sb=90n ploda1=16n ploda2=0 ploda3=0 plodb1=16n plodb2=0 \
        plodb3=0 nf_flag=1 smbt=1M smbb=1M dinsaflag=0 ppitch=0 spot=103n \
        spob=103n spotl1=103n spobl1=103n spotl2=103n spobl2=103n \
        spotr1=103n spobr1=103n spotr2=103n spobr2=103n
ends gm_x

// hybrid_final.scs — 混合仿真定稿版 (晶体管 VCO/DTC/SPD/CMP/GM + VA 数字)
simulator lang=spectre

include "/home/lib/tsmc_12nm_installed/pdk/models/toplevel.scs" section=top_tt
ahdl_include "/home/gmei/git/oephy/adpll/phase_va/pll_mmd_edge.va"
ahdl_include "/home/gmei/git/oephy/adpll/phase_va/pll_lms.va"
ahdl_include "/home/gmei/git/oephy/adpll/phase_va/pll_dtc_decoder.va"
ahdl_include "/home/gmei/git/oephy/adpll/phase_va/pll_hybrid_aux.va"

Vvdd (VDD 0) vsource dc=0.8
Vvss (VSS 0) vsource dc=0
Vref (REF 0) vsource type=pulse val0=0 val1=0.8 period=13.0208n width=6.5104n rise=10p fall=10p
Vbspd (VBSPD 0) vsource dc=0.24
Vbcmp (VBCMP 0) vsource dc=0.8
Vbgm  (VBGM 0) vsource dc=0.8

Xvco (VDD VSS VCTRL OUTP OUTN) vco_x
Xdtc (CK2X CKDTCD VDD VSS cd0 cd1 cd2 cd3 cd4 cd5 cd6 cd7 cd8 cd9 cd10 cd11 cd12 cd13 cd14 cd15 cd16 cd17 cd18 cd19 cd20 cd21 cd22 cd23 cd24 cd25 cd26 cd27 cd28 cd29 cd30 cd31 cd32 cd33 cd34 cd35 cd36 cd37 cd38 cd39 cd40 cd41 cd42 cd43 cd44 cd45 cd46 cd47 cd48 cd49 cd50 cd51 cd52 cd53 cd54 cd55 cd56 cd57 cd58 cd59 cd60 cd61 cd62 cd63 cd64 cd65 cd66 cd67 cd68 cd69 cd70 cd71 cd72 cd73 cd74 cd75 cd76 cd77 cd78 cd79 cd80 cd81 cd82 cd83 cd84 cd85 cd86 cd87 cd88 cd89 cd90 cd91 cd92 cd93 cd94 cd95 cd96 cd97 cd98 cd99 cd100 cd101 cd102 cd103 cd104 cd105 cd106 cd107 cd108 cd109 cd110 cd111 cd112 cd113 cd114 cd115 cd116 cd117 cd118 cd119 cd120 cd121 cd122 cd123 cd124 cd125 cd126 cd127 cd128 cd129 cd130 cd131 cd132 cd133 cd134 cd135 cd136 cd137 cd138 cd139 cd140 cd141 cd142 cd143 cd144 cd145 cd146 cd147 cd148 cd149 cd150 cd151 cd152 cd153 cd154 cd155 cd156 cd157 cd158 cd159 cd160 cd161 cd162 cd163 cd164 cd165 cd166 cd167 cd168 cd169 cd170 cd171 cd172 cd173 cd174 cd175 cd176 cd177 cd178 cd179 cd180 cd181 cd182 cd183 cd184 cd185 cd186 cd187 cd188 cd189 cd190 cd191 cd192 cd193 cd194 cd195 cd196 cd197 cd198 cd199 cd200 cd201 cd202 cd203 cd204 cd205 cd206 cd207 cd208 cd209 cd210 cd211 cd212 cd213 cd214 cd215 cd216 cd217 cd218 cd219 cd220 cd221 cd222 cd223 cd224 cd225 cd226 cd227 cd228 cd229 cd230 cd231 cd232 cd233 cd234 cd235 cd236 cd237 cd238 cd239 cd240 cd241 cd242 cd243 cd244 cd245 cd246 cd247 cd248 cd249 cd250 cd251 cd252 cd253 cd254 cd255 cd256 cd257 cd258 cd259 cd260 cd261 cd262 cd263 cd264 cd265 cd266 cd267 cd268 cd269 cd270 cd271 cd272 cd273 cd274 cd275 cd276 cd277 cd278 cd279 cd280 cd281 cd282 cd283 cd284 cd285 cd286 cd287 cd288 cd289 cd290 cd291 cd292 cd293 cd294 cd295 cd296 cd297 cd298 cd299 cd300 cd301 cd302 cd303 cd304 cd305 cd306 cd307 cd308 cd309 cd310 cd311 cd312 cd313 cd314 cd315 cd316 cd317 cd318 cd319 cd320 cd321 cd322 cd323 cd324 cd325 cd326 cd327 cd328 cd329 cd330 cd331 cd332 cd333 cd334 cd335 cd336 cd337 cd338 cd339 cd340 cd341 cd342 cd343 cd344 cd345 cd346 cd347 cd348 cd349 cd350 cd351 cd352 cd353 cd354 cd355 cd356 cd357 cd358 cd359 cd360 cd361 cd362 cd363 cd364 cd365 cd366 cd367 cd368 cd369 cd370 cd371 cd372 cd373 cd374 cd375 cd376 cd377 cd378 cd379 cd380 cd381 cd382 cd383 cd384 cd385 cd386 cd387 cd388 cd389 cd390 cd391 cd392 cd393 cd394 cd395 cd396 cd397 cd398 cd399 cd400 cd401 cd402 cd403 cd404 cd405 cd406 cd407 cd408 cd409 cd410 cd411 cd412 cd413 cd414 cd415 cd416 cd417 cd418 cd419 cd420 cd421 cd422 cd423 cd424 cd425 cd426 cd427 cd428 cd429 cd430 cd431 cd432 cd433 cd434 cd435 cd436 cd437 cd438 cd439 cd440 cd441 cd442 cd443 cd444 cd445 cd446 cd447 cd448 cd449 cd450 cd451 cd452 cd453 cd454 cd455 cd456 cd457 cd458 cd459 cd460 cd461 cd462 cd463 cd464 cd465 cd466 cd467 cd468 cd469 cd470 cd471 cd472 cd473 cd474 cd475 cd476 cd477 cd478 cd479 cd480 cd481 cd482 cd483 cd484 cd485 cd486 cd487 cd488 cd489 cd490 cd491 cd492 cd493 cd494 cd495 cd496 cd497 cd498 cd499 cd500 cd501 cd502 cd503 cd504 cd505 cd506 cd507 cd508 cd509 cd510) dtc_x
Xspd (VBSPD CKRST CKFB VHOLD VRAMP VDD VSS) spd_x
Xcmp (VHOLD VREF VBCMP EBIT VDD VSS) cmp_x
Xgm  (VHOLD VREF VBGM VI VDD VSS) gm_x

Xdbl (REF CK2X) pll_doubler_edge
Einv (CKRSTI 0 CKDTCD 0) vcvs gain=-1.0
Vrstofs (VDC08 0) vsource dc=0.8
Esumrst (CKRST VDC08 CKRSTI 0) vcvs gain=1.0

// ① 两级 CMOS 缓冲: VA cross 直连 VCO 节点会杀死振荡
Minvbuf_n (NBUF1 BUFFIN VSS VSS) nch_svt_mac l=16n nfin=2 w=58n multi=1 nf=4 \
        sd=74n sa=90n sb=90n ploda1=16n ploda2=0 ploda3=0 plodb1=16n \
        plodb2=0 plodb3=0 nf_flag=1 smbt=1M smbb=1M dinsaflag=0 ppitch=0 \
        spot=103n spob=103n spotl1=103n spobl1=103n spotl2=103n \
        spobl2=103n spotr1=103n spobr1=103n spotr2=103n spobr2=103n
Minvbuf_p (NBUF1 BUFFIN VDD VDD) pch_svt_mac l=16n nfin=2 w=58n multi=1 nf=4 \
        sd=74n sa=90n sb=90n ploda1=16n ploda2=0 ploda3=0 plodb1=16n \
        plodb2=0 plodb3=0 nf_flag=1 smbt=1M smbb=1M dinsaflag=0 ppitch=0 \
        spot=103n spob=103n spotl1=103n spobl1=103n spotl2=103n \
        spobl2=103n spotr1=103n spobr1=103n spotr2=103n spobr2=103n
Minvbuf2_n (MMDIN NBUF1 VSS VSS) nch_svt_mac l=16n nfin=2 w=58n multi=1 nf=4 \
        sd=74n sa=90n sb=90n ploda1=16n ploda2=0 ploda3=0 plodb1=16n \
        plodb2=0 plodb3=0 nf_flag=1 smbt=1M smbb=1M dinsaflag=0 ppitch=0 \
        spot=103n spob=103n spotl1=103n spobl1=103n spotl2=103n \
        spobl2=103n spotr1=103n spobr1=103n spotr2=103n spobr2=103n
Minvbuf2_p (MMDIN NBUF1 VDD VDD) pch_svt_mac l=16n nfin=2 w=58n multi=1 nf=4 \
        sd=74n sa=90n sb=90n ploda1=16n ploda2=0 ploda3=0 plodb1=16n \
        plodb2=0 plodb3=0 nf_flag=1 smbt=1M smbb=1M dinsaflag=0 ppitch=0 \
        spot=103n spob=103n spotl1=103n spobl1=103n spotl2=103n \
        spobl2=103n spotr1=103n spobr1=103n spotr2=103n spobr2=103n

// 缓冲前串联电阻: 平滑理想电感 VCO 的谐波扭结 (每 ~35 周期一次的 0.4 双穿越)
Rbuf (OUTP BUFFIN) resistor r=1k

Xmmd (MMDIN CKFB SEL ALT EPSC ERR) pll_mmd_edge Nint2=161.0 frac2=0.458333 vth=0.7
Xclkl (CKFB CLKLMS) pll_clk_lms
Xlms (CLKLMS EBIT SEL ALT EPSC KDTC VDCC RDCC VREF) pll_lms \
    mu_k=0.01 mu_v=5e-13 mu_r=1e-13 mu_off=4.2e-13 K0=1.0 vdcc0=12e-12 rdcc0=-12e-12 ohat0=32e-12 \
    offset_s=32e-12 vref0=0.40 fref=76.8e6 m_slope=1e9 mode=1 tscale=1e-6 seed=121
Xdec (CKFB KDTC EPSC SEL ALT VDCC RDCC c0 c1 c2 c3 c4 c5 c6 c7 c8 c9 c10 c11 c12 c13 c14 c15 c16 c17 c18 c19 c20 c21 c22 c23 c24 c25 c26 c27 c28 c29 c30 c31 c32 c33 c34 c35 c36 c37 c38 c39 c40 c41 c42 c43 c44 c45 c46 c47 c48 c49 c50 c51 c52 c53 c54 c55 c56 c57 c58 c59 c60 c61 c62 c63 c64 c65 c66 c67 c68 c69 c70 c71 c72 c73 c74 c75 c76 c77 c78 c79 c80 c81 c82 c83 c84 c85 c86 c87 c88 c89 c90 c91 c92 c93 c94 c95 c96 c97 c98 c99 c100 c101 c102 c103 c104 c105 c106 c107 c108 c109 c110 c111 c112 c113 c114 c115 c116 c117 c118 c119 c120 c121 c122 c123 c124 c125 c126 c127 c128 c129 c130 c131 c132 c133 c134 c135 c136 c137 c138 c139 c140 c141 c142 c143 c144 c145 c146 c147 c148 c149 c150 c151 c152 c153 c154 c155 c156 c157 c158 c159 c160 c161 c162 c163 c164 c165 c166 c167 c168 c169 c170 c171 c172 c173 c174 c175 c176 c177 c178 c179 c180 c181 c182 c183 c184 c185 c186 c187 c188 c189 c190 c191 c192 c193 c194 c195 c196 c197 c198 c199 c200 c201 c202 c203 c204 c205 c206 c207 c208 c209 c210 c211 c212 c213 c214 c215 c216 c217 c218 c219 c220 c221 c222 c223 c224 c225 c226 c227 c228 c229 c230 c231 c232 c233 c234 c235 c236 c237 c238 c239 c240 c241 c242 c243 c244 c245 c246 c247 c248 c249 c250 c251 c252 c253 c254 c255 c256 c257 c258 c259 c260 c261 c262 c263 c264 c265 c266 c267 c268 c269 c270 c271 c272 c273 c274 c275 c276 c277 c278 c279 c280 c281 c282 c283 c284 c285 c286 c287 c288 c289 c290 c291 c292 c293 c294 c295 c296 c297 c298 c299 c300 c301 c302 c303 c304 c305 c306 c307 c308 c309 c310 c311 c312 c313 c314 c315 c316 c317 c318 c319 c320 c321 c322 c323 c324 c325 c326 c327 c328 c329 c330 c331 c332 c333 c334 c335 c336 c337 c338 c339 c340 c341 c342 c343 c344 c345 c346 c347 c348 c349 c350 c351 c352 c353 c354 c355 c356 c357 c358 c359 c360 c361 c362 c363 c364 c365 c366 c367 c368 c369 c370 c371 c372 c373 c374 c375 c376 c377 c378 c379 c380 c381 c382 c383 c384 c385 c386 c387 c388 c389 c390 c391 c392 c393 c394 c395 c396 c397 c398 c399 c400 c401 c402 c403 c404 c405 c406 c407 c408 c409 c410 c411 c412 c413 c414 c415 c416 c417 c418 c419 c420 c421 c422 c423 c424 c425 c426 c427 c428 c429 c430 c431 c432 c433 c434 c435 c436 c437 c438 c439 c440 c441 c442 c443 c444 c445 c446 c447 c448 c449 c450 c451 c452 c453 c454 c455 c456 c457 c458 c459 c460 c461 c462 c463 c464 c465 c466 c467 c468 c469 c470 c471 c472 c473 c474 c475 c476 c477 c478 c479 c480 c481 c482 c483 c484 c485 c486 c487 c488 c489 c490 c491 c492 c493 c494 c495 c496 c497 c498 c499 c500 c501 c502 c503 c504 c505 c506 c507 c508 c509 c510) pll_dtc_decoder \
    fout=6.2e9 fref=76.8e6 frac2=0.458333 Tres=390e-15

Edec0 (cd0 0 CODE0 0) vcvs gain=1.0
Edec1 (cd1 0 CODE1 0) vcvs gain=1.0
Edec2 (cd2 0 CODE2 0) vcvs gain=1.0
Edec3 (cd3 0 CODE3 0) vcvs gain=1.0
Edec4 (cd4 0 CODE4 0) vcvs gain=1.0
Edec5 (cd5 0 CODE5 0) vcvs gain=1.0
Edec6 (cd6 0 CODE6 0) vcvs gain=1.0
Edec7 (cd7 0 CODE7 0) vcvs gain=1.0
Edec8 (cd8 0 CODE8 0) vcvs gain=1.0
Edec9 (cd9 0 CODE9 0) vcvs gain=1.0
Edec10 (cd10 0 CODE10 0) vcvs gain=1.0
Edec11 (cd11 0 CODE11 0) vcvs gain=1.0
Edec12 (cd12 0 CODE12 0) vcvs gain=1.0
Edec13 (cd13 0 CODE13 0) vcvs gain=1.0
Edec14 (cd14 0 CODE14 0) vcvs gain=1.0
Edec15 (cd15 0 CODE15 0) vcvs gain=1.0
Edec16 (cd16 0 CODE16 0) vcvs gain=1.0
Edec17 (cd17 0 CODE17 0) vcvs gain=1.0
Edec18 (cd18 0 CODE18 0) vcvs gain=1.0
Edec19 (cd19 0 CODE19 0) vcvs gain=1.0
Edec20 (cd20 0 CODE20 0) vcvs gain=1.0
Edec21 (cd21 0 CODE21 0) vcvs gain=1.0
Edec22 (cd22 0 CODE22 0) vcvs gain=1.0
Edec23 (cd23 0 CODE23 0) vcvs gain=1.0
Edec24 (cd24 0 CODE24 0) vcvs gain=1.0
Edec25 (cd25 0 CODE25 0) vcvs gain=1.0
Edec26 (cd26 0 CODE26 0) vcvs gain=1.0
Edec27 (cd27 0 CODE27 0) vcvs gain=1.0
Edec28 (cd28 0 CODE28 0) vcvs gain=1.0
Edec29 (cd29 0 CODE29 0) vcvs gain=1.0
Edec30 (cd30 0 CODE30 0) vcvs gain=1.0
Edec31 (cd31 0 CODE31 0) vcvs gain=1.0
Edec32 (cd32 0 CODE32 0) vcvs gain=1.0
Edec33 (cd33 0 CODE33 0) vcvs gain=1.0
Edec34 (cd34 0 CODE34 0) vcvs gain=1.0
Edec35 (cd35 0 CODE35 0) vcvs gain=1.0
Edec36 (cd36 0 CODE36 0) vcvs gain=1.0
Edec37 (cd37 0 CODE37 0) vcvs gain=1.0
Edec38 (cd38 0 CODE38 0) vcvs gain=1.0
Edec39 (cd39 0 CODE39 0) vcvs gain=1.0
Edec40 (cd40 0 CODE40 0) vcvs gain=1.0
Edec41 (cd41 0 CODE41 0) vcvs gain=1.0
Edec42 (cd42 0 CODE42 0) vcvs gain=1.0
Edec43 (cd43 0 CODE43 0) vcvs gain=1.0
Edec44 (cd44 0 CODE44 0) vcvs gain=1.0
Edec45 (cd45 0 CODE45 0) vcvs gain=1.0
Edec46 (cd46 0 CODE46 0) vcvs gain=1.0
Edec47 (cd47 0 CODE47 0) vcvs gain=1.0
Edec48 (cd48 0 CODE48 0) vcvs gain=1.0
Edec49 (cd49 0 CODE49 0) vcvs gain=1.0
Edec50 (cd50 0 CODE50 0) vcvs gain=1.0
Edec51 (cd51 0 CODE51 0) vcvs gain=1.0
Edec52 (cd52 0 CODE52 0) vcvs gain=1.0
Edec53 (cd53 0 CODE53 0) vcvs gain=1.0
Edec54 (cd54 0 CODE54 0) vcvs gain=1.0
Edec55 (cd55 0 CODE55 0) vcvs gain=1.0
Edec56 (cd56 0 CODE56 0) vcvs gain=1.0
Edec57 (cd57 0 CODE57 0) vcvs gain=1.0
Edec58 (cd58 0 CODE58 0) vcvs gain=1.0
Edec59 (cd59 0 CODE59 0) vcvs gain=1.0
Edec60 (cd60 0 CODE60 0) vcvs gain=1.0
Edec61 (cd61 0 CODE61 0) vcvs gain=1.0
Edec62 (cd62 0 CODE62 0) vcvs gain=1.0
Edec63 (cd63 0 CODE63 0) vcvs gain=1.0
Edec64 (cd64 0 CODE64 0) vcvs gain=1.0
Edec65 (cd65 0 CODE65 0) vcvs gain=1.0
Edec66 (cd66 0 CODE66 0) vcvs gain=1.0
Edec67 (cd67 0 CODE67 0) vcvs gain=1.0
Edec68 (cd68 0 CODE68 0) vcvs gain=1.0
Edec69 (cd69 0 CODE69 0) vcvs gain=1.0
Edec70 (cd70 0 CODE70 0) vcvs gain=1.0
Edec71 (cd71 0 CODE71 0) vcvs gain=1.0
Edec72 (cd72 0 CODE72 0) vcvs gain=1.0
Edec73 (cd73 0 CODE73 0) vcvs gain=1.0
Edec74 (cd74 0 CODE74 0) vcvs gain=1.0
Edec75 (cd75 0 CODE75 0) vcvs gain=1.0
Edec76 (cd76 0 CODE76 0) vcvs gain=1.0
Edec77 (cd77 0 CODE77 0) vcvs gain=1.0
Edec78 (cd78 0 CODE78 0) vcvs gain=1.0
Edec79 (cd79 0 CODE79 0) vcvs gain=1.0
Edec80 (cd80 0 CODE80 0) vcvs gain=1.0
Edec81 (cd81 0 CODE81 0) vcvs gain=1.0
Edec82 (cd82 0 CODE82 0) vcvs gain=1.0
Edec83 (cd83 0 CODE83 0) vcvs gain=1.0
Edec84 (cd84 0 CODE84 0) vcvs gain=1.0
Edec85 (cd85 0 CODE85 0) vcvs gain=1.0
Edec86 (cd86 0 CODE86 0) vcvs gain=1.0
Edec87 (cd87 0 CODE87 0) vcvs gain=1.0
Edec88 (cd88 0 CODE88 0) vcvs gain=1.0
Edec89 (cd89 0 CODE89 0) vcvs gain=1.0
Edec90 (cd90 0 CODE90 0) vcvs gain=1.0
Edec91 (cd91 0 CODE91 0) vcvs gain=1.0
Edec92 (cd92 0 CODE92 0) vcvs gain=1.0
Edec93 (cd93 0 CODE93 0) vcvs gain=1.0
Edec94 (cd94 0 CODE94 0) vcvs gain=1.0
Edec95 (cd95 0 CODE95 0) vcvs gain=1.0
Edec96 (cd96 0 CODE96 0) vcvs gain=1.0
Edec97 (cd97 0 CODE97 0) vcvs gain=1.0
Edec98 (cd98 0 CODE98 0) vcvs gain=1.0
Edec99 (cd99 0 CODE99 0) vcvs gain=1.0
Edec100 (cd100 0 CODE100 0) vcvs gain=1.0
Edec101 (cd101 0 CODE101 0) vcvs gain=1.0
Edec102 (cd102 0 CODE102 0) vcvs gain=1.0
Edec103 (cd103 0 CODE103 0) vcvs gain=1.0
Edec104 (cd104 0 CODE104 0) vcvs gain=1.0
Edec105 (cd105 0 CODE105 0) vcvs gain=1.0
Edec106 (cd106 0 CODE106 0) vcvs gain=1.0
Edec107 (cd107 0 CODE107 0) vcvs gain=1.0
Edec108 (cd108 0 CODE108 0) vcvs gain=1.0
Edec109 (cd109 0 CODE109 0) vcvs gain=1.0
Edec110 (cd110 0 CODE110 0) vcvs gain=1.0
Edec111 (cd111 0 CODE111 0) vcvs gain=1.0
Edec112 (cd112 0 CODE112 0) vcvs gain=1.0
Edec113 (cd113 0 CODE113 0) vcvs gain=1.0
Edec114 (cd114 0 CODE114 0) vcvs gain=1.0
Edec115 (cd115 0 CODE115 0) vcvs gain=1.0
Edec116 (cd116 0 CODE116 0) vcvs gain=1.0
Edec117 (cd117 0 CODE117 0) vcvs gain=1.0
Edec118 (cd118 0 CODE118 0) vcvs gain=1.0
Edec119 (cd119 0 CODE119 0) vcvs gain=1.0
Edec120 (cd120 0 CODE120 0) vcvs gain=1.0
Edec121 (cd121 0 CODE121 0) vcvs gain=1.0
Edec122 (cd122 0 CODE122 0) vcvs gain=1.0
Edec123 (cd123 0 CODE123 0) vcvs gain=1.0
Edec124 (cd124 0 CODE124 0) vcvs gain=1.0
Edec125 (cd125 0 CODE125 0) vcvs gain=1.0
Edec126 (cd126 0 CODE126 0) vcvs gain=1.0
Edec127 (cd127 0 CODE127 0) vcvs gain=1.0
Edec128 (cd128 0 CODE128 0) vcvs gain=1.0
Edec129 (cd129 0 CODE129 0) vcvs gain=1.0
Edec130 (cd130 0 CODE130 0) vcvs gain=1.0
Edec131 (cd131 0 CODE131 0) vcvs gain=1.0
Edec132 (cd132 0 CODE132 0) vcvs gain=1.0
Edec133 (cd133 0 CODE133 0) vcvs gain=1.0
Edec134 (cd134 0 CODE134 0) vcvs gain=1.0
Edec135 (cd135 0 CODE135 0) vcvs gain=1.0
Edec136 (cd136 0 CODE136 0) vcvs gain=1.0
Edec137 (cd137 0 CODE137 0) vcvs gain=1.0
Edec138 (cd138 0 CODE138 0) vcvs gain=1.0
Edec139 (cd139 0 CODE139 0) vcvs gain=1.0
Edec140 (cd140 0 CODE140 0) vcvs gain=1.0
Edec141 (cd141 0 CODE141 0) vcvs gain=1.0
Edec142 (cd142 0 CODE142 0) vcvs gain=1.0
Edec143 (cd143 0 CODE143 0) vcvs gain=1.0
Edec144 (cd144 0 CODE144 0) vcvs gain=1.0
Edec145 (cd145 0 CODE145 0) vcvs gain=1.0
Edec146 (cd146 0 CODE146 0) vcvs gain=1.0
Edec147 (cd147 0 CODE147 0) vcvs gain=1.0
Edec148 (cd148 0 CODE148 0) vcvs gain=1.0
Edec149 (cd149 0 CODE149 0) vcvs gain=1.0
Edec150 (cd150 0 CODE150 0) vcvs gain=1.0
Edec151 (cd151 0 CODE151 0) vcvs gain=1.0
Edec152 (cd152 0 CODE152 0) vcvs gain=1.0
Edec153 (cd153 0 CODE153 0) vcvs gain=1.0
Edec154 (cd154 0 CODE154 0) vcvs gain=1.0
Edec155 (cd155 0 CODE155 0) vcvs gain=1.0
Edec156 (cd156 0 CODE156 0) vcvs gain=1.0
Edec157 (cd157 0 CODE157 0) vcvs gain=1.0
Edec158 (cd158 0 CODE158 0) vcvs gain=1.0
Edec159 (cd159 0 CODE159 0) vcvs gain=1.0
Edec160 (cd160 0 CODE160 0) vcvs gain=1.0
Edec161 (cd161 0 CODE161 0) vcvs gain=1.0
Edec162 (cd162 0 CODE162 0) vcvs gain=1.0
Edec163 (cd163 0 CODE163 0) vcvs gain=1.0
Edec164 (cd164 0 CODE164 0) vcvs gain=1.0
Edec165 (cd165 0 CODE165 0) vcvs gain=1.0
Edec166 (cd166 0 CODE166 0) vcvs gain=1.0
Edec167 (cd167 0 CODE167 0) vcvs gain=1.0
Edec168 (cd168 0 CODE168 0) vcvs gain=1.0
Edec169 (cd169 0 CODE169 0) vcvs gain=1.0
Edec170 (cd170 0 CODE170 0) vcvs gain=1.0
Edec171 (cd171 0 CODE171 0) vcvs gain=1.0
Edec172 (cd172 0 CODE172 0) vcvs gain=1.0
Edec173 (cd173 0 CODE173 0) vcvs gain=1.0
Edec174 (cd174 0 CODE174 0) vcvs gain=1.0
Edec175 (cd175 0 CODE175 0) vcvs gain=1.0
Edec176 (cd176 0 CODE176 0) vcvs gain=1.0
Edec177 (cd177 0 CODE177 0) vcvs gain=1.0
Edec178 (cd178 0 CODE178 0) vcvs gain=1.0
Edec179 (cd179 0 CODE179 0) vcvs gain=1.0
Edec180 (cd180 0 CODE180 0) vcvs gain=1.0
Edec181 (cd181 0 CODE181 0) vcvs gain=1.0
Edec182 (cd182 0 CODE182 0) vcvs gain=1.0
Edec183 (cd183 0 CODE183 0) vcvs gain=1.0
Edec184 (cd184 0 CODE184 0) vcvs gain=1.0
Edec185 (cd185 0 CODE185 0) vcvs gain=1.0
Edec186 (cd186 0 CODE186 0) vcvs gain=1.0
Edec187 (cd187 0 CODE187 0) vcvs gain=1.0
Edec188 (cd188 0 CODE188 0) vcvs gain=1.0
Edec189 (cd189 0 CODE189 0) vcvs gain=1.0
Edec190 (cd190 0 CODE190 0) vcvs gain=1.0
Edec191 (cd191 0 CODE191 0) vcvs gain=1.0
Edec192 (cd192 0 CODE192 0) vcvs gain=1.0
Edec193 (cd193 0 CODE193 0) vcvs gain=1.0
Edec194 (cd194 0 CODE194 0) vcvs gain=1.0
Edec195 (cd195 0 CODE195 0) vcvs gain=1.0
Edec196 (cd196 0 CODE196 0) vcvs gain=1.0
Edec197 (cd197 0 CODE197 0) vcvs gain=1.0
Edec198 (cd198 0 CODE198 0) vcvs gain=1.0
Edec199 (cd199 0 CODE199 0) vcvs gain=1.0
Edec200 (cd200 0 CODE200 0) vcvs gain=1.0
Edec201 (cd201 0 CODE201 0) vcvs gain=1.0
Edec202 (cd202 0 CODE202 0) vcvs gain=1.0
Edec203 (cd203 0 CODE203 0) vcvs gain=1.0
Edec204 (cd204 0 CODE204 0) vcvs gain=1.0
Edec205 (cd205 0 CODE205 0) vcvs gain=1.0
Edec206 (cd206 0 CODE206 0) vcvs gain=1.0
Edec207 (cd207 0 CODE207 0) vcvs gain=1.0
Edec208 (cd208 0 CODE208 0) vcvs gain=1.0
Edec209 (cd209 0 CODE209 0) vcvs gain=1.0
Edec210 (cd210 0 CODE210 0) vcvs gain=1.0
Edec211 (cd211 0 CODE211 0) vcvs gain=1.0
Edec212 (cd212 0 CODE212 0) vcvs gain=1.0
Edec213 (cd213 0 CODE213 0) vcvs gain=1.0
Edec214 (cd214 0 CODE214 0) vcvs gain=1.0
Edec215 (cd215 0 CODE215 0) vcvs gain=1.0
Edec216 (cd216 0 CODE216 0) vcvs gain=1.0
Edec217 (cd217 0 CODE217 0) vcvs gain=1.0
Edec218 (cd218 0 CODE218 0) vcvs gain=1.0
Edec219 (cd219 0 CODE219 0) vcvs gain=1.0
Edec220 (cd220 0 CODE220 0) vcvs gain=1.0
Edec221 (cd221 0 CODE221 0) vcvs gain=1.0
Edec222 (cd222 0 CODE222 0) vcvs gain=1.0
Edec223 (cd223 0 CODE223 0) vcvs gain=1.0
Edec224 (cd224 0 CODE224 0) vcvs gain=1.0
Edec225 (cd225 0 CODE225 0) vcvs gain=1.0
Edec226 (cd226 0 CODE226 0) vcvs gain=1.0
Edec227 (cd227 0 CODE227 0) vcvs gain=1.0
Edec228 (cd228 0 CODE228 0) vcvs gain=1.0
Edec229 (cd229 0 CODE229 0) vcvs gain=1.0
Edec230 (cd230 0 CODE230 0) vcvs gain=1.0
Edec231 (cd231 0 CODE231 0) vcvs gain=1.0
Edec232 (cd232 0 CODE232 0) vcvs gain=1.0
Edec233 (cd233 0 CODE233 0) vcvs gain=1.0
Edec234 (cd234 0 CODE234 0) vcvs gain=1.0
Edec235 (cd235 0 CODE235 0) vcvs gain=1.0
Edec236 (cd236 0 CODE236 0) vcvs gain=1.0
Edec237 (cd237 0 CODE237 0) vcvs gain=1.0
Edec238 (cd238 0 CODE238 0) vcvs gain=1.0
Edec239 (cd239 0 CODE239 0) vcvs gain=1.0
Edec240 (cd240 0 CODE240 0) vcvs gain=1.0
Edec241 (cd241 0 CODE241 0) vcvs gain=1.0
Edec242 (cd242 0 CODE242 0) vcvs gain=1.0
Edec243 (cd243 0 CODE243 0) vcvs gain=1.0
Edec244 (cd244 0 CODE244 0) vcvs gain=1.0
Edec245 (cd245 0 CODE245 0) vcvs gain=1.0
Edec246 (cd246 0 CODE246 0) vcvs gain=1.0
Edec247 (cd247 0 CODE247 0) vcvs gain=1.0
Edec248 (cd248 0 CODE248 0) vcvs gain=1.0
Edec249 (cd249 0 CODE249 0) vcvs gain=1.0
Edec250 (cd250 0 CODE250 0) vcvs gain=1.0
Edec251 (cd251 0 CODE251 0) vcvs gain=1.0
Edec252 (cd252 0 CODE252 0) vcvs gain=1.0
Edec253 (cd253 0 CODE253 0) vcvs gain=1.0
Edec254 (cd254 0 CODE254 0) vcvs gain=1.0
Edec255 (cd255 0 CODE255 0) vcvs gain=1.0
Edec256 (cd256 0 CODE256 0) vcvs gain=1.0
Edec257 (cd257 0 CODE257 0) vcvs gain=1.0
Edec258 (cd258 0 CODE258 0) vcvs gain=1.0
Edec259 (cd259 0 CODE259 0) vcvs gain=1.0
Edec260 (cd260 0 CODE260 0) vcvs gain=1.0
Edec261 (cd261 0 CODE261 0) vcvs gain=1.0
Edec262 (cd262 0 CODE262 0) vcvs gain=1.0
Edec263 (cd263 0 CODE263 0) vcvs gain=1.0
Edec264 (cd264 0 CODE264 0) vcvs gain=1.0
Edec265 (cd265 0 CODE265 0) vcvs gain=1.0
Edec266 (cd266 0 CODE266 0) vcvs gain=1.0
Edec267 (cd267 0 CODE267 0) vcvs gain=1.0
Edec268 (cd268 0 CODE268 0) vcvs gain=1.0
Edec269 (cd269 0 CODE269 0) vcvs gain=1.0
Edec270 (cd270 0 CODE270 0) vcvs gain=1.0
Edec271 (cd271 0 CODE271 0) vcvs gain=1.0
Edec272 (cd272 0 CODE272 0) vcvs gain=1.0
Edec273 (cd273 0 CODE273 0) vcvs gain=1.0
Edec274 (cd274 0 CODE274 0) vcvs gain=1.0
Edec275 (cd275 0 CODE275 0) vcvs gain=1.0
Edec276 (cd276 0 CODE276 0) vcvs gain=1.0
Edec277 (cd277 0 CODE277 0) vcvs gain=1.0
Edec278 (cd278 0 CODE278 0) vcvs gain=1.0
Edec279 (cd279 0 CODE279 0) vcvs gain=1.0
Edec280 (cd280 0 CODE280 0) vcvs gain=1.0
Edec281 (cd281 0 CODE281 0) vcvs gain=1.0
Edec282 (cd282 0 CODE282 0) vcvs gain=1.0
Edec283 (cd283 0 CODE283 0) vcvs gain=1.0
Edec284 (cd284 0 CODE284 0) vcvs gain=1.0
Edec285 (cd285 0 CODE285 0) vcvs gain=1.0
Edec286 (cd286 0 CODE286 0) vcvs gain=1.0
Edec287 (cd287 0 CODE287 0) vcvs gain=1.0
Edec288 (cd288 0 CODE288 0) vcvs gain=1.0
Edec289 (cd289 0 CODE289 0) vcvs gain=1.0
Edec290 (cd290 0 CODE290 0) vcvs gain=1.0
Edec291 (cd291 0 CODE291 0) vcvs gain=1.0
Edec292 (cd292 0 CODE292 0) vcvs gain=1.0
Edec293 (cd293 0 CODE293 0) vcvs gain=1.0
Edec294 (cd294 0 CODE294 0) vcvs gain=1.0
Edec295 (cd295 0 CODE295 0) vcvs gain=1.0
Edec296 (cd296 0 CODE296 0) vcvs gain=1.0
Edec297 (cd297 0 CODE297 0) vcvs gain=1.0
Edec298 (cd298 0 CODE298 0) vcvs gain=1.0
Edec299 (cd299 0 CODE299 0) vcvs gain=1.0
Edec300 (cd300 0 CODE300 0) vcvs gain=1.0
Edec301 (cd301 0 CODE301 0) vcvs gain=1.0
Edec302 (cd302 0 CODE302 0) vcvs gain=1.0
Edec303 (cd303 0 CODE303 0) vcvs gain=1.0
Edec304 (cd304 0 CODE304 0) vcvs gain=1.0
Edec305 (cd305 0 CODE305 0) vcvs gain=1.0
Edec306 (cd306 0 CODE306 0) vcvs gain=1.0
Edec307 (cd307 0 CODE307 0) vcvs gain=1.0
Edec308 (cd308 0 CODE308 0) vcvs gain=1.0
Edec309 (cd309 0 CODE309 0) vcvs gain=1.0
Edec310 (cd310 0 CODE310 0) vcvs gain=1.0
Edec311 (cd311 0 CODE311 0) vcvs gain=1.0
Edec312 (cd312 0 CODE312 0) vcvs gain=1.0
Edec313 (cd313 0 CODE313 0) vcvs gain=1.0
Edec314 (cd314 0 CODE314 0) vcvs gain=1.0
Edec315 (cd315 0 CODE315 0) vcvs gain=1.0
Edec316 (cd316 0 CODE316 0) vcvs gain=1.0
Edec317 (cd317 0 CODE317 0) vcvs gain=1.0
Edec318 (cd318 0 CODE318 0) vcvs gain=1.0
Edec319 (cd319 0 CODE319 0) vcvs gain=1.0
Edec320 (cd320 0 CODE320 0) vcvs gain=1.0
Edec321 (cd321 0 CODE321 0) vcvs gain=1.0
Edec322 (cd322 0 CODE322 0) vcvs gain=1.0
Edec323 (cd323 0 CODE323 0) vcvs gain=1.0
Edec324 (cd324 0 CODE324 0) vcvs gain=1.0
Edec325 (cd325 0 CODE325 0) vcvs gain=1.0
Edec326 (cd326 0 CODE326 0) vcvs gain=1.0
Edec327 (cd327 0 CODE327 0) vcvs gain=1.0
Edec328 (cd328 0 CODE328 0) vcvs gain=1.0
Edec329 (cd329 0 CODE329 0) vcvs gain=1.0
Edec330 (cd330 0 CODE330 0) vcvs gain=1.0
Edec331 (cd331 0 CODE331 0) vcvs gain=1.0
Edec332 (cd332 0 CODE332 0) vcvs gain=1.0
Edec333 (cd333 0 CODE333 0) vcvs gain=1.0
Edec334 (cd334 0 CODE334 0) vcvs gain=1.0
Edec335 (cd335 0 CODE335 0) vcvs gain=1.0
Edec336 (cd336 0 CODE336 0) vcvs gain=1.0
Edec337 (cd337 0 CODE337 0) vcvs gain=1.0
Edec338 (cd338 0 CODE338 0) vcvs gain=1.0
Edec339 (cd339 0 CODE339 0) vcvs gain=1.0
Edec340 (cd340 0 CODE340 0) vcvs gain=1.0
Edec341 (cd341 0 CODE341 0) vcvs gain=1.0
Edec342 (cd342 0 CODE342 0) vcvs gain=1.0
Edec343 (cd343 0 CODE343 0) vcvs gain=1.0
Edec344 (cd344 0 CODE344 0) vcvs gain=1.0
Edec345 (cd345 0 CODE345 0) vcvs gain=1.0
Edec346 (cd346 0 CODE346 0) vcvs gain=1.0
Edec347 (cd347 0 CODE347 0) vcvs gain=1.0
Edec348 (cd348 0 CODE348 0) vcvs gain=1.0
Edec349 (cd349 0 CODE349 0) vcvs gain=1.0
Edec350 (cd350 0 CODE350 0) vcvs gain=1.0
Edec351 (cd351 0 CODE351 0) vcvs gain=1.0
Edec352 (cd352 0 CODE352 0) vcvs gain=1.0
Edec353 (cd353 0 CODE353 0) vcvs gain=1.0
Edec354 (cd354 0 CODE354 0) vcvs gain=1.0
Edec355 (cd355 0 CODE355 0) vcvs gain=1.0
Edec356 (cd356 0 CODE356 0) vcvs gain=1.0
Edec357 (cd357 0 CODE357 0) vcvs gain=1.0
Edec358 (cd358 0 CODE358 0) vcvs gain=1.0
Edec359 (cd359 0 CODE359 0) vcvs gain=1.0
Edec360 (cd360 0 CODE360 0) vcvs gain=1.0
Edec361 (cd361 0 CODE361 0) vcvs gain=1.0
Edec362 (cd362 0 CODE362 0) vcvs gain=1.0
Edec363 (cd363 0 CODE363 0) vcvs gain=1.0
Edec364 (cd364 0 CODE364 0) vcvs gain=1.0
Edec365 (cd365 0 CODE365 0) vcvs gain=1.0
Edec366 (cd366 0 CODE366 0) vcvs gain=1.0
Edec367 (cd367 0 CODE367 0) vcvs gain=1.0
Edec368 (cd368 0 CODE368 0) vcvs gain=1.0
Edec369 (cd369 0 CODE369 0) vcvs gain=1.0
Edec370 (cd370 0 CODE370 0) vcvs gain=1.0
Edec371 (cd371 0 CODE371 0) vcvs gain=1.0
Edec372 (cd372 0 CODE372 0) vcvs gain=1.0
Edec373 (cd373 0 CODE373 0) vcvs gain=1.0
Edec374 (cd374 0 CODE374 0) vcvs gain=1.0
Edec375 (cd375 0 CODE375 0) vcvs gain=1.0
Edec376 (cd376 0 CODE376 0) vcvs gain=1.0
Edec377 (cd377 0 CODE377 0) vcvs gain=1.0
Edec378 (cd378 0 CODE378 0) vcvs gain=1.0
Edec379 (cd379 0 CODE379 0) vcvs gain=1.0
Edec380 (cd380 0 CODE380 0) vcvs gain=1.0
Edec381 (cd381 0 CODE381 0) vcvs gain=1.0
Edec382 (cd382 0 CODE382 0) vcvs gain=1.0
Edec383 (cd383 0 CODE383 0) vcvs gain=1.0
Edec384 (cd384 0 CODE384 0) vcvs gain=1.0
Edec385 (cd385 0 CODE385 0) vcvs gain=1.0
Edec386 (cd386 0 CODE386 0) vcvs gain=1.0
Edec387 (cd387 0 CODE387 0) vcvs gain=1.0
Edec388 (cd388 0 CODE388 0) vcvs gain=1.0
Edec389 (cd389 0 CODE389 0) vcvs gain=1.0
Edec390 (cd390 0 CODE390 0) vcvs gain=1.0
Edec391 (cd391 0 CODE391 0) vcvs gain=1.0
Edec392 (cd392 0 CODE392 0) vcvs gain=1.0
Edec393 (cd393 0 CODE393 0) vcvs gain=1.0
Edec394 (cd394 0 CODE394 0) vcvs gain=1.0
Edec395 (cd395 0 CODE395 0) vcvs gain=1.0
Edec396 (cd396 0 CODE396 0) vcvs gain=1.0
Edec397 (cd397 0 CODE397 0) vcvs gain=1.0
Edec398 (cd398 0 CODE398 0) vcvs gain=1.0
Edec399 (cd399 0 CODE399 0) vcvs gain=1.0
Edec400 (cd400 0 CODE400 0) vcvs gain=1.0
Edec401 (cd401 0 CODE401 0) vcvs gain=1.0
Edec402 (cd402 0 CODE402 0) vcvs gain=1.0
Edec403 (cd403 0 CODE403 0) vcvs gain=1.0
Edec404 (cd404 0 CODE404 0) vcvs gain=1.0
Edec405 (cd405 0 CODE405 0) vcvs gain=1.0
Edec406 (cd406 0 CODE406 0) vcvs gain=1.0
Edec407 (cd407 0 CODE407 0) vcvs gain=1.0
Edec408 (cd408 0 CODE408 0) vcvs gain=1.0
Edec409 (cd409 0 CODE409 0) vcvs gain=1.0
Edec410 (cd410 0 CODE410 0) vcvs gain=1.0
Edec411 (cd411 0 CODE411 0) vcvs gain=1.0
Edec412 (cd412 0 CODE412 0) vcvs gain=1.0
Edec413 (cd413 0 CODE413 0) vcvs gain=1.0
Edec414 (cd414 0 CODE414 0) vcvs gain=1.0
Edec415 (cd415 0 CODE415 0) vcvs gain=1.0
Edec416 (cd416 0 CODE416 0) vcvs gain=1.0
Edec417 (cd417 0 CODE417 0) vcvs gain=1.0
Edec418 (cd418 0 CODE418 0) vcvs gain=1.0
Edec419 (cd419 0 CODE419 0) vcvs gain=1.0
Edec420 (cd420 0 CODE420 0) vcvs gain=1.0
Edec421 (cd421 0 CODE421 0) vcvs gain=1.0
Edec422 (cd422 0 CODE422 0) vcvs gain=1.0
Edec423 (cd423 0 CODE423 0) vcvs gain=1.0
Edec424 (cd424 0 CODE424 0) vcvs gain=1.0
Edec425 (cd425 0 CODE425 0) vcvs gain=1.0
Edec426 (cd426 0 CODE426 0) vcvs gain=1.0
Edec427 (cd427 0 CODE427 0) vcvs gain=1.0
Edec428 (cd428 0 CODE428 0) vcvs gain=1.0
Edec429 (cd429 0 CODE429 0) vcvs gain=1.0
Edec430 (cd430 0 CODE430 0) vcvs gain=1.0
Edec431 (cd431 0 CODE431 0) vcvs gain=1.0
Edec432 (cd432 0 CODE432 0) vcvs gain=1.0
Edec433 (cd433 0 CODE433 0) vcvs gain=1.0
Edec434 (cd434 0 CODE434 0) vcvs gain=1.0
Edec435 (cd435 0 CODE435 0) vcvs gain=1.0
Edec436 (cd436 0 CODE436 0) vcvs gain=1.0
Edec437 (cd437 0 CODE437 0) vcvs gain=1.0
Edec438 (cd438 0 CODE438 0) vcvs gain=1.0
Edec439 (cd439 0 CODE439 0) vcvs gain=1.0
Edec440 (cd440 0 CODE440 0) vcvs gain=1.0
Edec441 (cd441 0 CODE441 0) vcvs gain=1.0
Edec442 (cd442 0 CODE442 0) vcvs gain=1.0
Edec443 (cd443 0 CODE443 0) vcvs gain=1.0
Edec444 (cd444 0 CODE444 0) vcvs gain=1.0
Edec445 (cd445 0 CODE445 0) vcvs gain=1.0
Edec446 (cd446 0 CODE446 0) vcvs gain=1.0
Edec447 (cd447 0 CODE447 0) vcvs gain=1.0
Edec448 (cd448 0 CODE448 0) vcvs gain=1.0
Edec449 (cd449 0 CODE449 0) vcvs gain=1.0
Edec450 (cd450 0 CODE450 0) vcvs gain=1.0
Edec451 (cd451 0 CODE451 0) vcvs gain=1.0
Edec452 (cd452 0 CODE452 0) vcvs gain=1.0
Edec453 (cd453 0 CODE453 0) vcvs gain=1.0
Edec454 (cd454 0 CODE454 0) vcvs gain=1.0
Edec455 (cd455 0 CODE455 0) vcvs gain=1.0
Edec456 (cd456 0 CODE456 0) vcvs gain=1.0
Edec457 (cd457 0 CODE457 0) vcvs gain=1.0
Edec458 (cd458 0 CODE458 0) vcvs gain=1.0
Edec459 (cd459 0 CODE459 0) vcvs gain=1.0
Edec460 (cd460 0 CODE460 0) vcvs gain=1.0
Edec461 (cd461 0 CODE461 0) vcvs gain=1.0
Edec462 (cd462 0 CODE462 0) vcvs gain=1.0
Edec463 (cd463 0 CODE463 0) vcvs gain=1.0
Edec464 (cd464 0 CODE464 0) vcvs gain=1.0
Edec465 (cd465 0 CODE465 0) vcvs gain=1.0
Edec466 (cd466 0 CODE466 0) vcvs gain=1.0
Edec467 (cd467 0 CODE467 0) vcvs gain=1.0
Edec468 (cd468 0 CODE468 0) vcvs gain=1.0
Edec469 (cd469 0 CODE469 0) vcvs gain=1.0
Edec470 (cd470 0 CODE470 0) vcvs gain=1.0
Edec471 (cd471 0 CODE471 0) vcvs gain=1.0
Edec472 (cd472 0 CODE472 0) vcvs gain=1.0
Edec473 (cd473 0 CODE473 0) vcvs gain=1.0
Edec474 (cd474 0 CODE474 0) vcvs gain=1.0
Edec475 (cd475 0 CODE475 0) vcvs gain=1.0
Edec476 (cd476 0 CODE476 0) vcvs gain=1.0
Edec477 (cd477 0 CODE477 0) vcvs gain=1.0
Edec478 (cd478 0 CODE478 0) vcvs gain=1.0
Edec479 (cd479 0 CODE479 0) vcvs gain=1.0
Edec480 (cd480 0 CODE480 0) vcvs gain=1.0
Edec481 (cd481 0 CODE481 0) vcvs gain=1.0
Edec482 (cd482 0 CODE482 0) vcvs gain=1.0
Edec483 (cd483 0 CODE483 0) vcvs gain=1.0
Edec484 (cd484 0 CODE484 0) vcvs gain=1.0
Edec485 (cd485 0 CODE485 0) vcvs gain=1.0
Edec486 (cd486 0 CODE486 0) vcvs gain=1.0
Edec487 (cd487 0 CODE487 0) vcvs gain=1.0
Edec488 (cd488 0 CODE488 0) vcvs gain=1.0
Edec489 (cd489 0 CODE489 0) vcvs gain=1.0
Edec490 (cd490 0 CODE490 0) vcvs gain=1.0
Edec491 (cd491 0 CODE491 0) vcvs gain=1.0
Edec492 (cd492 0 CODE492 0) vcvs gain=1.0
Edec493 (cd493 0 CODE493 0) vcvs gain=1.0
Edec494 (cd494 0 CODE494 0) vcvs gain=1.0
Edec495 (cd495 0 CODE495 0) vcvs gain=1.0
Edec496 (cd496 0 CODE496 0) vcvs gain=1.0
Edec497 (cd497 0 CODE497 0) vcvs gain=1.0
Edec498 (cd498 0 CODE498 0) vcvs gain=1.0
Edec499 (cd499 0 CODE499 0) vcvs gain=1.0
Edec500 (cd500 0 CODE500 0) vcvs gain=1.0
Edec501 (cd501 0 CODE501 0) vcvs gain=1.0
Edec502 (cd502 0 CODE502 0) vcvs gain=1.0
Edec503 (cd503 0 CODE503 0) vcvs gain=1.0
Edec504 (cd504 0 CODE504 0) vcvs gain=1.0
Edec505 (cd505 0 CODE505 0) vcvs gain=1.0
Edec506 (cd506 0 CODE506 0) vcvs gain=1.0
Edec507 (cd507 0 CODE507 0) vcvs gain=1.0
Edec508 (cd508 0 CODE508 0) vcvs gain=1.0
Edec509 (cd509 0 CODE509 0) vcvs gain=1.0
Edec510 (cd510 0 CODE510 0) vcvs gain=1.0

Xci (VI 0) capacitor c=2p ic=0.55
Rf (VHOLD VHF) resistor r=5k
Cf (VHF 0) capacitor c=5p
; v2 fix: Ep 4-node vcvs (VN1 VHF 0 0) was unity-gain mis-wire, now true 0.06x
Ep (VN1 0 VHF 0) vcvs gain=0.06
Esum (VCTRL VN1 VI 0) vcvs gain=1.0

plltran tran stop=6u maxstep=2p errpreset=liberal method=gear2only skipdc=yes ic="OUTP=0.6"
save OUTP CKFB VCTRL VI VHOLD EBIT MMDIN NBUF1 VREF VDCC RDCC KDTC
