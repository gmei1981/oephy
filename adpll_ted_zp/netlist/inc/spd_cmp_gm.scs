// spd_cmp_gm.scs — SPD / comparator / GM subckts

subckt spd_x (VBIAS CK_RST CK_SMP VHOLD VRAMP VDD VSS)

MIR (VBSPD_M VBSPD_M VDD VDD) pch_svt_mac l=16n nfin=2 w=58n multi=1 nf=1  sd=74n sa=90n sb=90n ploda1=16n ploda2=0 ploda3=0 plodb1=16n \
        plodb2=0 plodb3=0 nf_flag=1 smbt=1M smbb=1M dinsaflag=0 ppitch=0 \
        spot=103n spob=103n spotl1=103n spobl1=103n spotl2=103n \
        spobl2=103n spotr1=103n spobr1=103n spotr2=103n spobr2=103n
RREF (VBSPD_M VSS) rhim l=38u w=450n multi=1
MCS (VRAMP VBSPD_M VDD VDD) pch_svt_mac l=16n nfin=2 w=58n multi=1 nf=1  sd=74n sa=90n sb=90n ploda1=16n ploda2=0 ploda3=0 plodb1=16n \
        plodb2=0 plodb3=0 nf_flag=1 smbt=1M smbb=1M dinsaflag=0 ppitch=0 \
        spot=103n spob=103n spotl1=103n spobl1=103n spotl2=103n \
        spobl2=103n spotr1=103n spobr1=103n spotr2=103n spobr2=103n
MSMP (VRAMP CK_SMP VHOLD VSS) nch_svt_mac l=16n nfin=2 w=58n multi=1 nf=8  sd=74n sa=90n sb=90n ploda1=16n ploda2=0 ploda3=0 plodb1=16n \
        plodb2=0 plodb3=0 nf_flag=1 smbt=1M smbb=1M dinsaflag=0 ppitch=0 \
        spot=103n spob=103n spotl1=103n spobl1=103n spotl2=103n \
        spobl2=103n spotr1=103n spobr1=103n spotr2=103n spobr2=103n
MRST (VRAMP CK_RST VSS VSS) nch_svt_mac l=16n nfin=2 w=58n multi=1 nf=32  sd=74n sa=90n sb=90n ploda1=16n ploda2=0 ploda3=0 plodb1=16n \
        plodb2=0 plodb3=0 nf_flag=1 smbt=1M smbb=1M dinsaflag=0 ppitch=0 \
        spot=103n spob=103n spotl1=103n spobl1=103n spotl2=103n \
        spobl2=103n spotr1=103n spobr1=103n spotr2=103n spobr2=103n
CH (VHOLD VSS VSS) cfmom_wo_p80 dmflag=0 lr=1u multi=1 mxd_flag=0 nr=12         n_mxa=2 shield=2 spm=3 stm=1 vapmod=2 grflag=1 gdis_t=185n         gdis_b=185n gdis_l=102n gdis_r=102n
CR0 (VRAMP VSS) capacitor c=30f
ends spd_x

subckt cmp_x (VINP VINN VBIAS EOUT VDD VSS)

MN3 (EOUT OUTP1 VSS VSS) nch_svt_mac l=16n nfin=2 w=58n multi=1 nf=2 \
        sd=74n sa=90n sb=90n ploda1=16n ploda2=0 ploda3=0 plodb1=16n \
        plodb2=0 plodb3=0 nf_flag=1 smbt=1M smbb=1M dinsaflag=0 ppitch=0 \
        spot=103n spob=103n spotl1=103n spobl1=103n spotl2=103n \
        spobl2=103n spotr1=103n spobr1=103n spotr2=103n spobr2=103n
MN2 (OUTP1 VINP TAILN VSS) nch_svt_mac l=16n nfin=2 w=58n multi=1 nf=2 \
        sd=74n sa=90n sb=90n ploda1=16n ploda2=0 ploda3=0 plodb1=16n \
        plodb2=0 plodb3=0 nf_flag=1 smbt=1M smbb=1M dinsaflag=0 ppitch=0 \
        spot=103n spob=103n spotl1=103n spobl1=103n spotl2=103n \
        spobl2=103n spotr1=103n spobr1=103n spotr2=103n spobr2=103n
MN1 (OUTN1 VINN TAILN VSS) nch_svt_mac l=16n nfin=2 w=58n multi=1 nf=2 \
        sd=74n sa=90n sb=90n ploda1=16n ploda2=0 ploda3=0 plodb1=16n \
        plodb2=0 plodb3=0 nf_flag=1 smbt=1M smbb=1M dinsaflag=0 ppitch=0 \
        spot=103n spob=103n spotl1=103n spobl1=103n spotl2=103n \
        spobl2=103n spotr1=103n spobr1=103n spotr2=103n spobr2=103n
MTAIL (TAILN VBIAS VSS VSS) nch_svt_mac l=16n nfin=2 w=58n multi=1 nf=2 \
        sd=74n sa=90n sb=90n ploda1=16n ploda2=0 ploda3=0 plodb1=16n \
        plodb2=0 plodb3=0 nf_flag=1 smbt=1M smbb=1M dinsaflag=0 ppitch=0 \
        spot=103n spob=103n spotl1=103n spobl1=103n spotl2=103n \
        spobl2=103n spotr1=103n spobr1=103n spotr2=103n spobr2=103n
MP3 (EOUT OUTP1 VDD VDD) pch_svt_mac l=16n nfin=2 w=58n multi=1 nf=2 \
        sd=74n sa=90n sb=90n ploda1=16n ploda2=0 ploda3=0 plodb1=16n \
        plodb2=0 plodb3=0 nf_flag=1 smbt=1M smbb=1M dinsaflag=0 ppitch=0 \
        spot=103n spob=103n spotl1=103n spobl1=103n spotl2=103n \
        spobl2=103n spotr1=103n spobr1=103n spotr2=103n spobr2=103n
MP2 (OUTP1 OUTN1 VDD VDD) pch_svt_mac l=16n nfin=2 w=58n multi=1 nf=2 \
        sd=74n sa=90n sb=90n ploda1=16n ploda2=0 ploda3=0 plodb1=16n \
        plodb2=0 plodb3=0 nf_flag=1 smbt=1M smbb=1M dinsaflag=0 ppitch=0 \
        spot=103n spob=103n spotl1=103n spobl1=103n spotl2=103n \
        spobl2=103n spotr1=103n spobr1=103n spotr2=103n spobr2=103n
MP1 (OUTN1 OUTN1 VDD VDD) pch_svt_mac l=16n nfin=2 w=58n multi=1 nf=2 \
        sd=74n sa=90n sb=90n ploda1=16n ploda2=0 ploda3=0 plodb1=16n \
        plodb2=0 plodb3=0 nf_flag=1 smbt=1M smbb=1M dinsaflag=0 ppitch=0 \
        spot=103n spob=103n spotl1=103n spobl1=103n spotl2=103n \
        spobl2=103n spotr1=103n spobr1=103n spotr2=103n spobr2=103n
ends cmp_x

subckt gm_x (VINP VINN VBIAS IOUT VDD VSS)

; wp5 fix: input pair svt->ulvt (Vth 0.45->0.3) so GM conducts at the
; Plan C 0.5V-core working point (VHOLD~0.3, VREF~0.45); svt was the wp4
; root cause of dead GM (VI slip with no frequency authority)
MN2 (IOUT VINN TAILN VSS) nch_ulvt_mac l=16n nfin=2 w=58n multi=1 nf=1 \
        sd=74n sa=90n sb=90n ploda1=16n ploda2=0 ploda3=0 plodb1=16n \
        plodb2=0 plodb3=0 nf_flag=1 smbt=1M smbb=1M dinsaflag=0 ppitch=0 \
        spot=103n spob=103n spotl1=103n spobl1=103n spotl2=103n \
        spobl2=103n spotr1=103n spobr1=103n spotr2=103n spobr2=103n
MN1 (OUTN VINP TAILN VSS) nch_ulvt_mac l=16n nfin=2 w=58n multi=1 nf=1 \
        sd=74n sa=90n sb=90n ploda1=16n ploda2=0 ploda3=0 plodb1=16n \
        plodb2=0 plodb3=0 nf_flag=1 smbt=1M smbb=1M dinsaflag=0 ppitch=0 \
        spot=103n spob=103n spotl1=103n spobl1=103n spotl2=103n \
        spobl2=103n spotr1=103n spobr1=103n spotr2=103n spobr2=103n
MTAIL (TAILN VBIAS VSS VSS) nch_svt_mac l=16n nfin=2 w=58n multi=1 nf=1 \
        sd=74n sa=90n sb=90n ploda1=16n ploda2=0 ploda3=0 plodb1=16n \
        plodb2=0 plodb3=0 nf_flag=1 smbt=1M smbb=1M dinsaflag=0 ppitch=0 \
        spot=103n spob=103n spotl1=103n spobl1=103n spotl2=103n \
        spobl2=103n spotr1=103n spobr1=103n spotr2=103n spobr2=103n
; v2 fix: GM mirror 1/4.5 - pull-up 8.4nA->1.9nA, symmetric with pull-down
MP2 (IOUT OUTN VDD VDD) pch_svt_mac l=72n nfin=2 w=58n multi=1 nf=1 sd=74n \
        sa=90n sb=90n ploda1=16n ploda2=0 ploda3=0 plodb1=16n plodb2=0 \
        plodb3=0 nf_flag=1 smbt=1M smbb=1M dinsaflag=0 ppitch=0 spot=103n \
        spob=103n spotl1=103n spobl1=103n spotl2=103n spobl2=103n \
        spotr1=103n spobr1=103n spotr2=103n spobr2=103n
MP1 (OUTN OUTN VDD VDD) pch_svt_mac l=16n nfin=2 w=58n multi=1 nf=1 sd=74n \
        sa=90n sb=90n ploda1=16n ploda2=0 ploda3=0 plodb1=16n plodb2=0 \
        plodb3=0 nf_flag=1 smbt=1M smbb=1M dinsaflag=0 ppitch=0 spot=103n \
        spob=103n spotl1=103n spobl1=103n spotl2=103n spobl2=103n \
        spotr1=103n spobr1=103n spotr2=103n spobr2=103n
ends gm_x
