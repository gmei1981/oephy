; build_dtc_10b.il - generated by tools/build_dtc_10b.py (plan A)
cv = dbOpenCellViewByType("adpll_sch" "dtc_10b" "schematic" "schematic" "a")

procedure(dtcProp(inst prop val)
  unless(dbFindProp(inst prop)
    dbCreateProp(inst prop "string" val)
    dbReplaceProp(inst prop "string" val)))

procedure(dtcTermCtr(inst termName)
  let((term pin fig bb)
    term = car(setof(tt inst~>master~>terminals tt~>name == termName))
    pin = when(term car(term~>pins))
    fig = when(pin car(pin~>figs))
    bb = when(fig fig~>bBox)
    when(bb
      dbTransformPoint(
        list((xCoord(car(bb)) + xCoord(cadr(bb))) / 2.0
             (yCoord(car(bb)) + yCoord(cadr(bb))) / 2.0)
        inst~>transform))))

procedure(dtcStub(inst termName netName dx dy)
  let((ctr end mid)
    ctr = dtcTermCtr(inst termName)
    when(ctr
      end = list(xCoord(ctr) + dx yCoord(ctr) + dy)
      mid = list((xCoord(ctr) + xCoord(end)) / 2.0
                 (yCoord(ctr) + yCoord(end)) / 2.0)
      schCreateWire(cv "route" "full" list(ctr end) 0 0 0 nil nil)
      schCreateWireLabel(cv nil mid netName "centerCenter" "R0" "stick" 0.0625 nil))))

procedure(dtcPinAt(pinName dir x y)
  let((master)
    master = dbOpenCellViewByType("basic"
      cond((dir == "input" "ipin") (dir == "output" "opin") (t "iopin"))
      "symbol")
    schCreatePin(cv master pinName dir nil x:y "R0")
    schCreateWire(cv "route" "full" list(x:y x+0.5:y) 0 0 0 nil nil)
    schCreateWireLabel(cv nil x+0.25:y pinName "centerCenter" "R0" "stick" 0.0625 nil)))

; ---------------- decoder VA inside DTC ----------------
xdec = dbCreateInstByMasterName(cv "adpll_sch" "pll_dtc_decoder_10b" "symbol" "Xdec" 4:26 "R0")
dtcProp(xdec "fout" "8.000000e+09")
dtcProp(xdec "fref" "1.000000e+08")
dtcProp(xdec "frac2" "0.0")
dtcProp(xdec "Tres" "3.300000e-16")

; ---------------- peripherals ----------------
r0 = dbCreateInstByMasterName(cv "tsmcN12" "rhim" "symbol" "R0" 10:20 "R0")
dtcProp(r0 "l" "2.3e-06")
dtcProp(r0 "w" "2e-06")
mni = dbCreateInstByMasterName(cv "tsmcN12" "nch_svt_mac" "symbol" "MNI" 14:20 "R0")
mpi = dbCreateInstByMasterName(cv "tsmcN12" "pch_svt_mac" "symbol" "MPI" 16:20 "R0")
mrst = dbCreateInstByMasterName(cv "tsmcN12" "nch_svt_mac" "symbol" "MRST_D" 18:20 "R0")
dtcProp(mrst "fingers" "2") dtcProp(mrst "nf" "2")
mn1 = dbCreateInstByMasterName(cv "tsmcN12" "nch_svt_mac" "symbol" "MN1" 22:20 "R0")
dtcProp(mn1 "fingers" "8") dtcProp(mn1 "nf" "8")
mp1 = dbCreateInstByMasterName(cv "tsmcN12" "pch_svt_mac" "symbol" "MP1" 24:20 "R0")
dtcProp(mp1 "fingers" "8") dtcProp(mp1 "nf" "8")

dtcStub(r0 "PLUS" "CK_IN" -0.25 0)
dtcStub(r0 "MINUS" "VDLY" 0.25 0)
dtcStub(mni "G" "CK_IN" -0.25 0)
dtcStub(mni "D" "CKXB" 0 0.25)
dtcStub(mni "S" "VSS" 0 -0.25)
dtcStub(mni "B" "VSS" 0.25 0)
dtcStub(mpi "G" "CK_IN" -0.25 0)
dtcStub(mpi "D" "CKXB" 0 -0.25)
dtcStub(mpi "S" "VDD" 0 0.25)
dtcStub(mpi "B" "VDD" 0.25 0)
dtcStub(mrst "G" "CKXB" -0.25 0)
dtcStub(mrst "D" "VDLY" 0 0.25)
dtcStub(mrst "S" "VSS" 0 -0.25)
dtcStub(mrst "B" "VSS" 0.25 0)
dtcStub(mn1 "G" "VDLY" -0.25 0)
dtcStub(mn1 "D" "CK_OUT" 0 0.25)
dtcStub(mn1 "S" "VSS" 0 -0.25)
dtcStub(mn1 "B" "VSS" 0.25 0)
dtcStub(mp1 "G" "VDLY" -0.25 0)
dtcStub(mp1 "D" "CK_OUT" 0 -0.25)
dtcStub(mp1 "S" "VDD" 0 0.25)
dtcStub(mp1 "B" "VDD" 0.25 0)

; ---------------- 33x31 grid: 1023 switch+cap pairs ----------------
for(row 0 32
  for(col 0 30
    let((i x y uname cname ui ci)
      i = row*31 + col
      x = 150.0 + col*2.5
      y = 26.0 - row*2.0
      uname = sprintf(nil "U%d" i)
      cname = sprintf(nil "C%d" i)
      ui = dbCreateInstByMasterName(cv "tsmcN12" "nch_svt_mac" "symbol" uname x:y "R0")
      dtcProp(ui "fingers" "2")
      dtcProp(ui "nf" "2")
      ci = dbCreateInstByMasterName(cv "analogLib" "cap" "symbol" cname x+1.2:y "R0")
      dtcProp(ci "c" "5e-16")
      dtcStub(ui "G" sprintf(nil "c%d" i) -0.25 0)
      dtcStub(ui "D" "VDLY" 0 0.25)
      dtcStub(ui "S" sprintf(nil "UCAP%d" i) 0 -0.25)
      dtcStub(ui "B" "VSS" 0.25 0)
      dtcStub(ci "PLUS" sprintf(nil "UCAP%d" i) 0 0.25)
      dtcStub(ci "MINUS" "VSS" 0 -0.25))))

; ---------------- Xdec pin stubs (uppercase control nets, c<i> lowercase) ----
foreach(tname xdec~>master~>terminals~>name
  let((net)
    net = cond(
      (tname == "ckfb" "CKFB")
      (tname == "kdtc" "KDTC")
      (tname == "epsc" "EPSC")
      (tname == "sel" "SEL")
      (tname == "alt" "ALT")
      (tname == "vdcc" "VDCC")
      (tname == "rdcc" "RDCC")
      (t tname))
    dtcStub(xdec tname net 0 0.3)))

; ---------------- 11 pins at left edge, creation order = subckt header ----
dtcPinAt("CK_IN" "input" 1.0 18.0)
dtcPinAt("CK_OUT" "output" 1.0 16.0)
dtcPinAt("VDD" "inputOutput" 1.0 14.0)
dtcPinAt("VSS" "inputOutput" 1.0 12.0)
dtcPinAt("CKFB" "input" 1.0 10.0)
dtcPinAt("KDTC" "input" 1.0 8.0)
dtcPinAt("EPSC" "input" 1.0 6.0)
dtcPinAt("SEL" "input" 1.0 4.0)
dtcPinAt("ALT" "input" 1.0 2.0)
dtcPinAt("VDCC" "input" 1.0 0.0)
dtcPinAt("RDCC" "input" 1.0 -2.0)

printf("DTC_BUILD_DONE instances=%d\n" length(cv~>instances))
