// VCO 开环相噪标定: PSS+pnoise, 双核/单核 (论文 Fig.15 比对: -101/-98.1 dBc/Hz @100kHz @3G输出)
// 用法: --dual 通过 EN2 电压选择; VCTRL 扫工作点
simulator lang=spectre
include "/home/lib/tsmc_12nm_installed/pdk/models/toplevel.scs" section=top_tt
include "vco_dual.scs"

Vvdd (VDD 0) vsource dc=0.8
Vvss (VSS 0) vsource dc=0
Vctrl (VCTRL 0) vsource dc=0.5
Ven2 (EN2 0) vsource dc=0.8

Xvco (VDD VSS VCTRL OUTP OUTN EN2) vco_dual
Rloadp (OUTP 0) resistor r=1e6
Rloadn (OUTN 0) resistor r=1e6

pllpss (OUTP OUTN) pss fund=6.1G harms=10 errpreset=liberal tstab=60n maxstep=1p
pllpnoise (OUTP OUTN) pnoise start=10k stop=100M maxsideband=20 refsideband=0 \
    type=log points=200 op=1
