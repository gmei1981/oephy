// cmp_x 瞬态延迟: VINP 0.2->0.6 线性斜坡(200ps), 在 t=10.1ns 跨过 VREF=0.4
simulator lang=spectre
include "/home/lib/tsmc_12nm_installed/pdk/models/toplevel.scs" section=top_tt
include "spd_cmp_gm.scs"
Vvdd (VDD 0) vsource dc=0.8
Vvss (VSS 0) vsource dc=0
Vb (VBCMP 0) vsource dc=0.8
Vr (VREF 0) vsource dc=0.4
Vi (VINP 0) vsource type=pwl wave=[0 0.2 10n 0.2 10.2n 0.6 50n 0.6]
Xcmp (VINP VREF VBCMP EBIT VDD VSS) cmp_x
plltran tran stop=30n maxstep=5p errpreset=liberal method=gear2only skipdc=yes
save VINP EBIT
