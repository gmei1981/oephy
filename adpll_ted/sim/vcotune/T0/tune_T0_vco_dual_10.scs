// vcotune T0_vco_dual_10
simulator lang=spectre
include "/home/lib/tsmc_12nm_installed/pdk/models/toplevel.scs" section=top_tt
include "vco_dual_tuned.scs"
Vvdd (VDD 0) vsource dc=0.8
Vvss (VSS 0) vsource dc=0
Vctrl (VCTRL 0) vsource dc=1.0
Venv2 (EN2 0) vsource dc=0.8
Xvco (VDD VSS VCTRL OUTP OUTN EN2) vco_dual
vctran tran stop=12n maxstep=1p errpreset=liberal method=gear2only
save OUTP
