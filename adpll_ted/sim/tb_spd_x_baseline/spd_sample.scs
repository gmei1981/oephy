// SPD 采样演示: CKDTC 153.6M, CKFB 在斜坡中段(1.6ns 处)发 0.5ns 采样脉冲
simulator lang=spectre
include "/home/lib/tsmc_12nm_installed/pdk/models/toplevel.scs" section=top_tt
include "spd_cmp_gm.scs"
Vvdd (VDD 0) vsource dc=0.8
Vvss (VSS 0) vsource dc=0
Vb (VBSPD 0) vsource dc=0.33
Vck (CKDTC 0) vsource type=pulse val0=0 val1=0.8 period=6.5104n width=3.255n rise=20p fall=20p
Vfb (CKFB 0) vsource type=pulse val0=0 val1=0.8 period=6.5104n delay=1.6n width=0.5n rise=20p fall=20p
Vrst (VDC08 0) vsource dc=0.8
Ein (CKRSTI 0 CKDTC 0) vcvs gain=-1.0
Es (CKRST VDC08 CKRSTI 0) vcvs gain=1.0
Xspd (VBSPD CKRST CKFB VHOLD VRAMP VDD VSS) spd_x
plltran tran stop=30n maxstep=10p errpreset=liberal method=gear2only skipdc=yes
save CKDTC CKFB VRAMP VHOLD
