// vco_c_dac.scs — generated by tools/gen_vco_c_dac.py (ref2 SS-BB-ADPLL single core)
// core supply VDDC=0.5V from LDO (ldo_05.scs); logic domain VDD=0.8V
// VC1/VC2 = ideal DAC outputs (0-0.5V) direct-driving varactor bulks:
//   VC1 coarse: nfin=24 moscap/side (~206MHz/V)  <- DAC1 (7-bit)
//   VC2 fine:   nfin=2  moscap/side (~5-20MHz/V) <- DAC2 (9-bit)
// no enable switches / no bleeders (switch-threshold root cause removed)

// glitch DUT: vco_x_c_dac core (proven LC startup) + ONE EN-switched
// differential VAR unit (GU0p/GU0n, moscap nfin=2 + NMOS gate switch)
// == the fbank unit-switching event under test. 2026-09-14
parameters NFIN_U=2 NF_SW=2

subckt vco_glitch_dut (VDD VDDC VSS OUTP OUTN VC1 VC2 EN VSW)
MN1 (OUTP OUTN TAIL VSS) nch_ulvt_mac l=16n nfin=2 w=58n multi=1 sd=74n sa=90n sb=90n ploda1=16n ploda2=0 ploda3=0 plodb1=16n plodb2=0 plodb3=0 nf_flag=1 smbt=1M smbb=1M dinsaflag=0 ppitch=0 spot=103n spob=103n spotl1=103n spobl1=103n spotl2=103n spobl2=103n spotr1=103n spobr1=103n spotr2=103n spobr2=103n nf=16
MN0 (OUTN OUTP TAIL VSS) nch_ulvt_mac l=16n nfin=2 w=58n multi=1 sd=74n sa=90n sb=90n ploda1=16n ploda2=0 ploda3=0 plodb1=16n plodb2=0 plodb3=0 nf_flag=1 smbt=1M smbb=1M dinsaflag=0 ppitch=0 spot=103n spob=103n spotl1=103n spobl1=103n spotl2=103n spobl2=103n spotr1=103n spobr1=103n spotr2=103n spobr2=103n nf=16
Ls (TAIL VSS) inductor l=2n r=1
L1 (VDD OUTN) inductor l=1.5n r=2
L0 (VDD OUTP) inductor l=1.5n r=2
Cbyp (VDD VSS) capacitor c=10p
CF0 (OUTP OUTN VSS) cfmom_wo_p80 dmflag=0 lr=1u multi=1 mxd_flag=0 nr=174 n_mxa=2 shield=2 spm=3 stm=1 vapmod=2 grflag=1 gdis_t=185n gdis_b=185n gdis_l=102n gdis_r=102n
CF1 (OUTN net01 VSS) cfmom_wo_p80 dmflag=0 lr=1u multi=1 mxd_flag=0 nr=174 n_mxa=2 shield=2 spm=3 stm=1 vapmod=2 grflag=1 gdis_t=185n gdis_b=185n gdis_l=102n gdis_r=102n
CF2 (OUTN net02 VSS) cfmom_wo_p80 dmflag=0 lr=1u multi=1 mxd_flag=0 nr=174 n_mxa=2 shield=2 spm=3 stm=1 vapmod=2 grflag=1 gdis_t=185n gdis_b=185n gdis_l=102n gdis_r=102n
CF3 (OUTN net03 VSS) cfmom_wo_p80 dmflag=0 lr=1u multi=1 mxd_flag=0 nr=174 n_mxa=2 shield=2 spm=3 stm=1 vapmod=2 grflag=1 gdis_t=185n gdis_b=185n gdis_l=102n gdis_r=102n
CF4 (OUTN net04 VSS) cfmom_wo_p80 dmflag=0 lr=1u multi=1 mxd_flag=0 nr=174 n_mxa=2 shield=2 spm=3 stm=1 vapmod=2 grflag=1 gdis_t=185n gdis_b=185n gdis_l=102n gdis_r=102n
CF5 (OUTN net05 VSS) cfmom_wo_p80 dmflag=0 lr=1u multi=1 mxd_flag=0 nr=174 n_mxa=2 shield=2 spm=3 stm=1 vapmod=2 grflag=1 gdis_t=185n gdis_b=185n gdis_l=102n gdis_r=102n
CF6 (OUTP OUTN VSS) cfmom_wo_p80 dmflag=0 lr=1u multi=1 mxd_flag=0 nr=174 n_mxa=2 shield=2 spm=3 stm=1 vapmod=2 grflag=1 gdis_t=185n gdis_b=185n gdis_l=102n gdis_r=102n
CF7 (OUTN net07 VSS) cfmom_wo_p80 dmflag=0 lr=1u multi=1 mxd_flag=0 nr=174 n_mxa=2 shield=2 spm=3 stm=1 vapmod=2 grflag=1 gdis_t=185n gdis_b=185n gdis_l=102n gdis_r=102n
CF8 (OUTN net08 VSS) cfmom_wo_p80 dmflag=0 lr=1u multi=1 mxd_flag=0 nr=174 n_mxa=2 shield=2 spm=3 stm=1 vapmod=2 grflag=1 gdis_t=185n gdis_b=185n gdis_l=102n gdis_r=102n
CF9 (OUTN net09 VSS) cfmom_wo_p80 dmflag=0 lr=1u multi=1 mxd_flag=0 nr=174 n_mxa=2 shield=2 spm=3 stm=1 vapmod=2 grflag=1 gdis_t=185n gdis_b=185n gdis_l=102n gdis_r=102n
CF10 (OUTN net10 VSS) cfmom_wo_p80 dmflag=0 lr=1u multi=1 mxd_flag=0 nr=174 n_mxa=2 shield=2 spm=3 stm=1 vapmod=2 grflag=1 gdis_t=185n gdis_b=185n gdis_l=102n gdis_r=102n
CF11 (OUTN net11 VSS) cfmom_wo_p80 dmflag=0 lr=1u multi=1 mxd_flag=0 nr=174 n_mxa=2 shield=2 spm=3 stm=1 vapmod=2 grflag=1 gdis_t=185n gdis_b=185n gdis_l=102n gdis_r=102n
C1p_mv (OUTP VC1 VC1) moscap_rf wr=538n lr=200n gr=2 br=2 multi=1 sobn=470n sobs=470n sobw=684n sobe=684n nfin=24
C1n_mv (OUTN VC1 VC1) moscap_rf wr=538n lr=200n gr=2 br=2 multi=1 sobn=470n sobs=470n sobw=684n sobe=684n nfin=24
C2p_mv (OUTP VC2 VC2) moscap_rf wr=538n lr=200n gr=2 br=2 multi=1 sobn=470n sobs=470n sobw=684n sobe=684n nfin=2
C2n_mv (OUTN VC2 VC2) moscap_rf wr=538n lr=200n gr=2 br=2 multi=1 sobn=470n sobs=470n sobw=684n sobe=684n nfin=2
// ---- unit under test: EN=0.8 -> cb tied to VSW (varactor biased); EN=0 -> cb floats
VI00p_mv (OUTP GU0p_cb GU0p_cb) moscap_rf wr=538n lr=200n gr=2 br=2 multi=1 sobn=470n sobs=470n sobw=684n sobe=684n nfin=NFIN_U
VI00p_sw (GU0p_cb EN VSW VSS) nch_ulvt_mac l=16n nfin=2 w=58n multi=1 sd=74n sa=90n sb=90n ploda1=16n ploda2=0 ploda3=0 plodb1=16n plodb2=0 plodb3=0 nf_flag=1 smbt=1M smbb=1M dinsaflag=0 ppitch=0 spot=103n spob=103n spotl1=103n spobl1=103n spotl2=103n spobl2=103n spotr1=103n spobr1=103n spotr2=103n spobr2=103n nf=NF_SW
VI00n_mv (OUTN GU0n_cb GU0n_cb) moscap_rf wr=538n lr=200n gr=2 br=2 multi=1 sobn=470n sobs=470n sobw=684n sobe=684n nfin=NFIN_U
VI00n_sw (GU0n_cb EN VSW VSS) nch_ulvt_mac l=16n nfin=2 w=58n multi=1 sd=74n sa=90n sb=90n ploda1=16n ploda2=0 ploda3=0 plodb1=16n plodb2=0 plodb3=0 nf_flag=1 smbt=1M smbb=1M dinsaflag=0 ppitch=0 spot=103n spob=103n spotl1=103n spobl1=103n spotl2=103n spobl2=103n spotr1=103n spobr1=103n spotr2=103n spobr2=103n nf=NF_SW
ends vco_x_c_dac
