// pll_ssbb_main.scs — generated by tools/gen_ssbb_top.py (ref2 SS-BB-ADPLL)
// integer channel 100M/8G (FCW=0); AFC target=320 = 2G*160ns window
// V3 AFC-only closed loop: no BBPD/DLF/GS; AFC code -> dac7 -> VC1,
// VC2 fixed 0.25V (KVCO1 sweep reference). Expect code 64->~80,
// AFC_DONE ~1.3us, fVCO 8.00G +-25MHz (count tol).
simulator lang=spectre

include "/home/lib/tsmc_12nm_installed/pdk/models/toplevel.scs" section=top_tt
ahdl_include "netlist/va/pll_afc.va"
ahdl_include "netlist/va/pll_dac7.va"
ahdl_include "netlist/va/pll_div4.va"
include "netlist/inc/ldo_05.scs"
include "netlist/inc/vco_c_dac.scs"

// --- sources ---
Vvdd (VDD 0) vsource dc=0.8
Vvss (VSS 0) vsource dc=0
Vref (REF 0) vsource type=pulse val0=0 val1=0.8 period=10n width=5n rise=10p fall=10p
Vv1v (V1V 0) vsource dc=1.0
Vvbg (VBG 0) vsource dc=0.5
Vvbl (VBL 0) vsource dc=0.62

// --- LDO: 1.0V -> 0.5V VCO core supply ---
Xldo (VDD V1V VBG VBL VDDC VSS) ldo_05

// --- reference path: REF -> DTC(CODE) -> CKR ---

// V3: AFC code directly through the ideal coarse DAC
Xdac1 (VC1 A0 A1 A2 A3 A4 A5 A6) pll_dac7 vmax=0.5
Vc2 (VC2 0) vsource dc=0.25

// --- VCO + buffer + /4 feedback ---
// vco_x_c_dac 'VDD' port = tank supply -> tie to 0.5V VDDC (as the dual
// wrapper does: Xa(VDDC ...)); subckt VDDC port is unused inside, tie too
Xvco (VDDC VDDC VSS OUTP OUTN VC1 VC2) vco_x_c_dac
Rbuf (OUTP BUFFIN) resistor r=1k
// two-stage 0.8V-domain inverter buffer (proven in hyb top)
    Minvb1_n (NBUF1 BUFFIN VSS VSS) nch_svt_mac l=16n nfin=2 w=58n multi=1 nf=4 sd=74n sa=90n sb=90n ploda1=16n ploda2=0 ploda3=0 plodb1=16n plodb2=0 plodb3=0 nf_flag=1 smbt=1M smbb=1M dinsaflag=0 ppitch=0 spot=103n spob=103n spotl1=103n spobl1=103n spotl2=103n spobl2=103n spotr1=103n spobr1=103n spotr2=103n spobr2=103n
    Minvb1_p (NBUF1 BUFFIN VDD VDD) pch_svt_mac l=16n nfin=2 w=58n multi=1 nf=4 sd=74n sa=90n sb=90n ploda1=16n ploda2=0 ploda3=0 plodb1=16n plodb2=0 plodb3=0 nf_flag=1 smbt=1M smbb=1M dinsaflag=0 ppitch=0 spot=103n spob=103n spotl1=103n spobl1=103n spotl2=103n spobl2=103n spotr1=103n spobr1=103n spotr2=103n spobr2=103n
    Minvb2_n (OUTPB NBUF1 VSS VSS) nch_svt_mac l=16n nfin=2 w=58n multi=1 nf=4 sd=74n sa=90n sb=90n ploda1=16n ploda2=0 ploda3=0 plodb1=16n plodb2=0 plodb3=0 nf_flag=1 smbt=1M smbb=1M dinsaflag=0 ppitch=0 spot=103n spob=103n spotl1=103n spobl1=103n spotl2=103n spobl2=103n spotr1=103n spobr1=103n spotr2=103n spobr2=103n
    Minvb2_p (OUTPB NBUF1 VDD VDD) pch_svt_mac l=16n nfin=2 w=58n multi=1 nf=4 sd=74n sa=90n sb=90n ploda1=16n ploda2=0 ploda3=0 plodb1=16n plodb2=0 plodb3=0 nf_flag=1 smbt=1M smbb=1M dinsaflag=0 ppitch=0 spot=103n spob=103n spotl1=103n spobl1=103n spotl2=103n spobl2=103n spotr1=103n spobr1=103n spotr2=103n spobr2=103n
Xdiv4 (OUTPB DIV4) pll_div4 vth=0.5

// --- AFC + GS ---
Xafc (REF DIV4 A0 A1 A2 A3 A4 A5 A6 AFC_DONE CNTOUT) pll_afc target=320 K=16

plltran tran stop=2u maxstep=2p errpreset=liberal method=gear2only skipdc=yes ic="OUTP=0.45" ic="OUTN=0.0"
save REF VC1 VC2 DIV4 OUTP OUTPB VDDC AFC_DONE CNTOUT A0 A1 A2 A3 A4 A5 A6
saveOptions options save=selected
