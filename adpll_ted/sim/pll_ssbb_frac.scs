// pll_ssbb_main.scs — generated by tools/gen_ssbb_top.py (ref2 SS-BB-ADPLL)
// integer channel 100M/8G (FCW=0); AFC target=320 = 2G*160ns window
simulator lang=spectre

include "/home/lib/tsmc_12nm_installed/pdk/models/toplevel.scs" section=top_tt
ahdl_include "netlist/va/pll_afc.va"
ahdl_include "netlist/va/pll_dac7.va"
ahdl_include "netlist/va/pll_div4.va"
ahdl_include "netlist/va/pll_bbpd.va"
ahdl_include "netlist/va/pll_dlf.va"
ahdl_include "netlist/va/pll_dac9.va"
ahdl_include "netlist/va/pll_gs.va"
ahdl_include "netlist/va/pll_frac_acc.va"
ahdl_include "netlist/va/pll_dtc_code.va"
include "netlist/inc/ldo_05.scs"
include "netlist/inc/vco_c_dac.scs"
include "netlist/inc/dtc_10b_ss.scs"

// --- sources ---
Vvdd (VDD 0) vsource dc=0.8
Vvss (VSS 0) vsource dc=0
Vref (REF 0) vsource type=pulse val0=0 val1=0.8 period=10n width=5n rise=10p fall=10p
Vv1v (V1V 0) vsource dc=1.0
Vvbg (VBG 0) vsource dc=0.5
Vvbl (VBL 0) vsource dc=0.62

// --- LDO: 1.0V -> 0.5V VCO core supply ---
Xldo (VDD V1V VBG VBL VDDC VSS) ldo_05

// --- reference path: REF -> DTC(CODE) -> CKR ---
Xacc (REF D0 D1 D2 D3 D4 D5 D6 D7 D8 D9) pll_frac_acc FCW=401
Xdtc (REF CKR VDD VSS D0 D1 D2 D3 D4 D5 D6 D7 D8 D9) dtc_10b_ss

// --- BBPD + DLF + DACs ---
Xbbpd (CKR DIV4 BB BB_DZ) pll_bbpd vth=0.4 Tdz=50p
Xdlf (CKR BB AFC_DONE A0 A1 A2 A3 A4 A5 A6 KP KI C0 C1 C2 C3 C4 C5 C6 C7 C8 C9 C10 C11 C12 C13 C14 C15) pll_dlf
Xdac1 (VC1 C9 C10 C11 C12 C13 C14 C15) pll_dac7 vmax=0.5
Xdac2 (VC2 C0 C1 C2 C3 C4 C5 C6 C7 C8) pll_dac9 vmax=0.5

// --- VCO + buffer + /4 feedback ---
// vco_x_c_dac 'VDD' port = tank supply -> tie to 0.5V VDDC (as the dual
// wrapper does: Xa(VDDC ...)); subckt VDDC port is unused inside, tie too
Xvco (VDDC VDDC VSS OUTP OUTN VC1 VC2) vco_x_c_dac
Rbuf (OUTP BUFFIN) resistor r=1k
// two-stage 0.8V-domain inverter buffer (proven in hyb top)
    Minvb1_n (NBUF1 BUFFIN VSS VSS) nch_svt_mac l=16n nfin=2 w=58n multi=1 nf=4 sd=74n sa=90n sb=90n ploda1=16n ploda2=0 ploda3=0 plodb1=16n plodb2=0 plodb3=0 nf_flag=1 smbt=1M smbb=1M dinsaflag=0 ppitch=0 spot=103n spob=103n spotl1=103n spobl1=103n spotl2=103n spobl2=103n spotr1=103n spobr1=103n spotr2=103n spobr2=103n
    Minvb1_p (NBUF1 BUFFIN VDD VDD) pch_svt_mac l=16n nfin=2 w=58n multi=1 nf=4 sd=74n sa=90n sb=90n ploda1=16n ploda2=0 ploda3=0 plodb1=16n plodb2=0 plodb3=0 nf_flag=1 smbt=1M smbb=1M dinsaflag=0 ppitch=0 spot=103n spob=103n spotl1=103n spobl1=103n spotl2=103n spobl2=103n spotr1=103n spobr1=103n spotr2=103n spobr2=103n
    Minvb2_n (OUTPB NBUF1 VSS VSS) nch_svt_mac l=16n nfin=2 w=58n multi=1 nf=4 sd=74n sa=90n sb=90n ploda1=16n ploda2=0 ploda3=0 plodb1=16n plodb2=0 plodb3=0 nf_flag=1 smbt=1M smbb=1M dinsaflag=0 ppitch=0 spot=103n spob=103n spotl1=103n spobl1=103n spotl2=103n spobl2=103n spotr1=103n spobr1=103n spotr2=103n spobr2=103n
    Minvb2_p (OUTPB NBUF1 VDD VDD) pch_svt_mac l=16n nfin=2 w=58n multi=1 nf=4 sd=74n sa=90n sb=90n ploda1=16n ploda2=0 ploda3=0 plodb1=16n plodb2=0 plodb3=0 nf_flag=1 smbt=1M smbb=1M dinsaflag=0 ppitch=0 spot=103n spob=103n spotl1=103n spobl1=103n spotl2=103n spobl2=103n spotr1=103n spobr1=103n spotr2=103n spobr2=103n
Xdiv4 (OUTPB DIV4) pll_div4 vth=0.5

// --- AFC + GS ---
// integer: target=320 (8G/4*160ns); fractional 8.05G: 322
Xafc (REF DIV4 A0 A1 A2 A3 A4 A5 A6 AFC_DONE CNTOUT) pll_afc target=322 K=16
Xgs (REF BB BB_DZ AFC_DONE G0 G1 G2 KP KI) pll_gs W=128 THR=4

plltran tran stop=1.2u maxstep=2p errpreset=liberal method=gear2only skipdc=yes ic="OUTP=0.45" ic="OUTN=0.0"
save REF CKR BB BB_DZ VC1 VC2 DIV4 OUTP OUTPB VDDC AFC_DONE KP KI G0 G1 G2 C9 C15 CNTOUT A0 A1 A2 A3 A4 A5 A6
saveOptions options save=selected
