// pll_dtc_decoder.va — LMS 校准输出 → 511 温度计栅压 (晶体管 DTC 驱动)
// code = round((kdtc·QE_sec + sel·vdcc + alt·rdcc)/Tres); 温度计映射 code+255 (0..510)
// 每 CKFB 沿更新 (与 phase_va 的逐周期码同构)
`include "constants.vams"
`include "disciplines.vams"

module pll_dtc_decoder(ckfb, kdtc, epsc, sel, alt, vdcc, rdcc, c0, c1, c2, c3, c4, c5, c6, c7, c8, c9, c10, c11, c12, c13, c14, c15, c16, c17, c18, c19, c20, c21, c22, c23, c24, c25, c26, c27, c28, c29, c30, c31, c32, c33, c34, c35, c36, c37, c38, c39, c40, c41, c42, c43, c44, c45, c46, c47, c48, c49, c50, c51, c52, c53, c54, c55, c56, c57, c58, c59, c60, c61, c62, c63, c64, c65, c66, c67, c68, c69, c70, c71, c72, c73, c74, c75, c76, c77, c78, c79, c80, c81, c82, c83, c84, c85, c86, c87, c88, c89, c90, c91, c92, c93, c94, c95, c96, c97, c98, c99, c100, c101, c102, c103, c104, c105, c106, c107, c108, c109, c110, c111, c112, c113, c114, c115, c116, c117, c118, c119, c120, c121, c122, c123, c124, c125, c126, c127, c128, c129, c130, c131, c132, c133, c134, c135, c136, c137, c138, c139, c140, c141, c142, c143, c144, c145, c146, c147, c148, c149, c150, c151, c152, c153, c154, c155, c156, c157, c158, c159, c160, c161, c162, c163, c164, c165, c166, c167, c168, c169, c170, c171, c172, c173, c174, c175, c176, c177, c178, c179, c180, c181, c182, c183, c184, c185, c186, c187, c188, c189, c190, c191, c192, c193, c194, c195, c196, c197, c198, c199, c200, c201, c202, c203, c204, c205, c206, c207, c208, c209, c210, c211, c212, c213, c214, c215, c216, c217, c218, c219, c220, c221, c222, c223, c224, c225, c226, c227, c228, c229, c230, c231, c232, c233, c234, c235, c236, c237, c238, c239, c240, c241, c242, c243, c244, c245, c246, c247, c248, c249, c250, c251, c252, c253, c254, c255, c256, c257, c258, c259, c260, c261, c262, c263, c264, c265, c266, c267, c268, c269, c270, c271, c272, c273, c274, c275, c276, c277, c278, c279, c280, c281, c282, c283, c284, c285, c286, c287, c288, c289, c290, c291, c292, c293, c294, c295, c296, c297, c298, c299, c300, c301, c302, c303, c304, c305, c306, c307, c308, c309, c310, c311, c312, c313, c314, c315, c316, c317, c318, c319, c320, c321, c322, c323, c324, c325, c326, c327, c328, c329, c330, c331, c332, c333, c334, c335, c336, c337, c338, c339, c340, c341, c342, c343, c344, c345, c346, c347, c348, c349, c350, c351, c352, c353, c354, c355, c356, c357, c358, c359, c360, c361, c362, c363, c364, c365, c366, c367, c368, c369, c370, c371, c372, c373, c374, c375, c376, c377, c378, c379, c380, c381, c382, c383, c384, c385, c386, c387, c388, c389, c390, c391, c392, c393, c394, c395, c396, c397, c398, c399, c400, c401, c402, c403, c404, c405, c406, c407, c408, c409, c410, c411, c412, c413, c414, c415, c416, c417, c418, c419, c420, c421, c422, c423, c424, c425, c426, c427, c428, c429, c430, c431, c432, c433, c434, c435, c436, c437, c438, c439, c440, c441, c442, c443, c444, c445, c446, c447, c448, c449, c450, c451, c452, c453, c454, c455, c456, c457, c458, c459, c460, c461, c462, c463, c464, c465, c466, c467, c468, c469, c470, c471, c472, c473, c474, c475, c476, c477, c478, c479, c480, c481, c482, c483, c484, c485, c486, c487, c488, c489, c490, c491, c492, c493, c494, c495, c496, c497, c498, c499, c500, c501, c502, c503, c504, c505, c506, c507, c508, c509, c510);
inout ckfb, kdtc, epsc, sel, alt, vdcc, rdcc;
inout c0;
inout c1;
inout c2;
inout c3;
inout c4;
inout c5;
inout c6;
inout c7;
inout c8;
inout c9;
inout c10;
inout c11;
inout c12;
inout c13;
inout c14;
inout c15;
inout c16;
inout c17;
inout c18;
inout c19;
inout c20;
inout c21;
inout c22;
inout c23;
inout c24;
inout c25;
inout c26;
inout c27;
inout c28;
inout c29;
inout c30;
inout c31;
inout c32;
inout c33;
inout c34;
inout c35;
inout c36;
inout c37;
inout c38;
inout c39;
inout c40;
inout c41;
inout c42;
inout c43;
inout c44;
inout c45;
inout c46;
inout c47;
inout c48;
inout c49;
inout c50;
inout c51;
inout c52;
inout c53;
inout c54;
inout c55;
inout c56;
inout c57;
inout c58;
inout c59;
inout c60;
inout c61;
inout c62;
inout c63;
inout c64;
inout c65;
inout c66;
inout c67;
inout c68;
inout c69;
inout c70;
inout c71;
inout c72;
inout c73;
inout c74;
inout c75;
inout c76;
inout c77;
inout c78;
inout c79;
inout c80;
inout c81;
inout c82;
inout c83;
inout c84;
inout c85;
inout c86;
inout c87;
inout c88;
inout c89;
inout c90;
inout c91;
inout c92;
inout c93;
inout c94;
inout c95;
inout c96;
inout c97;
inout c98;
inout c99;
inout c100;
inout c101;
inout c102;
inout c103;
inout c104;
inout c105;
inout c106;
inout c107;
inout c108;
inout c109;
inout c110;
inout c111;
inout c112;
inout c113;
inout c114;
inout c115;
inout c116;
inout c117;
inout c118;
inout c119;
inout c120;
inout c121;
inout c122;
inout c123;
inout c124;
inout c125;
inout c126;
inout c127;
inout c128;
inout c129;
inout c130;
inout c131;
inout c132;
inout c133;
inout c134;
inout c135;
inout c136;
inout c137;
inout c138;
inout c139;
inout c140;
inout c141;
inout c142;
inout c143;
inout c144;
inout c145;
inout c146;
inout c147;
inout c148;
inout c149;
inout c150;
inout c151;
inout c152;
inout c153;
inout c154;
inout c155;
inout c156;
inout c157;
inout c158;
inout c159;
inout c160;
inout c161;
inout c162;
inout c163;
inout c164;
inout c165;
inout c166;
inout c167;
inout c168;
inout c169;
inout c170;
inout c171;
inout c172;
inout c173;
inout c174;
inout c175;
inout c176;
inout c177;
inout c178;
inout c179;
inout c180;
inout c181;
inout c182;
inout c183;
inout c184;
inout c185;
inout c186;
inout c187;
inout c188;
inout c189;
inout c190;
inout c191;
inout c192;
inout c193;
inout c194;
inout c195;
inout c196;
inout c197;
inout c198;
inout c199;
inout c200;
inout c201;
inout c202;
inout c203;
inout c204;
inout c205;
inout c206;
inout c207;
inout c208;
inout c209;
inout c210;
inout c211;
inout c212;
inout c213;
inout c214;
inout c215;
inout c216;
inout c217;
inout c218;
inout c219;
inout c220;
inout c221;
inout c222;
inout c223;
inout c224;
inout c225;
inout c226;
inout c227;
inout c228;
inout c229;
inout c230;
inout c231;
inout c232;
inout c233;
inout c234;
inout c235;
inout c236;
inout c237;
inout c238;
inout c239;
inout c240;
inout c241;
inout c242;
inout c243;
inout c244;
inout c245;
inout c246;
inout c247;
inout c248;
inout c249;
inout c250;
inout c251;
inout c252;
inout c253;
inout c254;
inout c255;
inout c256;
inout c257;
inout c258;
inout c259;
inout c260;
inout c261;
inout c262;
inout c263;
inout c264;
inout c265;
inout c266;
inout c267;
inout c268;
inout c269;
inout c270;
inout c271;
inout c272;
inout c273;
inout c274;
inout c275;
inout c276;
inout c277;
inout c278;
inout c279;
inout c280;
inout c281;
inout c282;
inout c283;
inout c284;
inout c285;
inout c286;
inout c287;
inout c288;
inout c289;
inout c290;
inout c291;
inout c292;
inout c293;
inout c294;
inout c295;
inout c296;
inout c297;
inout c298;
inout c299;
inout c300;
inout c301;
inout c302;
inout c303;
inout c304;
inout c305;
inout c306;
inout c307;
inout c308;
inout c309;
inout c310;
inout c311;
inout c312;
inout c313;
inout c314;
inout c315;
inout c316;
inout c317;
inout c318;
inout c319;
inout c320;
inout c321;
inout c322;
inout c323;
inout c324;
inout c325;
inout c326;
inout c327;
inout c328;
inout c329;
inout c330;
inout c331;
inout c332;
inout c333;
inout c334;
inout c335;
inout c336;
inout c337;
inout c338;
inout c339;
inout c340;
inout c341;
inout c342;
inout c343;
inout c344;
inout c345;
inout c346;
inout c347;
inout c348;
inout c349;
inout c350;
inout c351;
inout c352;
inout c353;
inout c354;
inout c355;
inout c356;
inout c357;
inout c358;
inout c359;
inout c360;
inout c361;
inout c362;
inout c363;
inout c364;
inout c365;
inout c366;
inout c367;
inout c368;
inout c369;
inout c370;
inout c371;
inout c372;
inout c373;
inout c374;
inout c375;
inout c376;
inout c377;
inout c378;
inout c379;
inout c380;
inout c381;
inout c382;
inout c383;
inout c384;
inout c385;
inout c386;
inout c387;
inout c388;
inout c389;
inout c390;
inout c391;
inout c392;
inout c393;
inout c394;
inout c395;
inout c396;
inout c397;
inout c398;
inout c399;
inout c400;
inout c401;
inout c402;
inout c403;
inout c404;
inout c405;
inout c406;
inout c407;
inout c408;
inout c409;
inout c410;
inout c411;
inout c412;
inout c413;
inout c414;
inout c415;
inout c416;
inout c417;
inout c418;
inout c419;
inout c420;
inout c421;
inout c422;
inout c423;
inout c424;
inout c425;
inout c426;
inout c427;
inout c428;
inout c429;
inout c430;
inout c431;
inout c432;
inout c433;
inout c434;
inout c435;
inout c436;
inout c437;
inout c438;
inout c439;
inout c440;
inout c441;
inout c442;
inout c443;
inout c444;
inout c445;
inout c446;
inout c447;
inout c448;
inout c449;
inout c450;
inout c451;
inout c452;
inout c453;
inout c454;
inout c455;
inout c456;
inout c457;
inout c458;
inout c459;
inout c460;
inout c461;
inout c462;
inout c463;
inout c464;
inout c465;
inout c466;
inout c467;
inout c468;
inout c469;
inout c470;
inout c471;
inout c472;
inout c473;
inout c474;
inout c475;
inout c476;
inout c477;
inout c478;
inout c479;
inout c480;
inout c481;
inout c482;
inout c483;
inout c484;
inout c485;
inout c486;
inout c487;
inout c488;
inout c489;
inout c490;
inout c491;
inout c492;
inout c493;
inout c494;
inout c495;
inout c496;
inout c497;
inout c498;
inout c499;
inout c500;
inout c501;
inout c502;
inout c503;
inout c504;
inout c505;
inout c506;
inout c507;
inout c508;
inout c509;
inout c510;
electrical ckfb, kdtc, epsc, sel, alt, vdcc, rdcc;
electrical c0;
electrical c1;
electrical c2;
electrical c3;
electrical c4;
electrical c5;
electrical c6;
electrical c7;
electrical c8;
electrical c9;
electrical c10;
electrical c11;
electrical c12;
electrical c13;
electrical c14;
electrical c15;
electrical c16;
electrical c17;
electrical c18;
electrical c19;
electrical c20;
electrical c21;
electrical c22;
electrical c23;
electrical c24;
electrical c25;
electrical c26;
electrical c27;
electrical c28;
electrical c29;
electrical c30;
electrical c31;
electrical c32;
electrical c33;
electrical c34;
electrical c35;
electrical c36;
electrical c37;
electrical c38;
electrical c39;
electrical c40;
electrical c41;
electrical c42;
electrical c43;
electrical c44;
electrical c45;
electrical c46;
electrical c47;
electrical c48;
electrical c49;
electrical c50;
electrical c51;
electrical c52;
electrical c53;
electrical c54;
electrical c55;
electrical c56;
electrical c57;
electrical c58;
electrical c59;
electrical c60;
electrical c61;
electrical c62;
electrical c63;
electrical c64;
electrical c65;
electrical c66;
electrical c67;
electrical c68;
electrical c69;
electrical c70;
electrical c71;
electrical c72;
electrical c73;
electrical c74;
electrical c75;
electrical c76;
electrical c77;
electrical c78;
electrical c79;
electrical c80;
electrical c81;
electrical c82;
electrical c83;
electrical c84;
electrical c85;
electrical c86;
electrical c87;
electrical c88;
electrical c89;
electrical c90;
electrical c91;
electrical c92;
electrical c93;
electrical c94;
electrical c95;
electrical c96;
electrical c97;
electrical c98;
electrical c99;
electrical c100;
electrical c101;
electrical c102;
electrical c103;
electrical c104;
electrical c105;
electrical c106;
electrical c107;
electrical c108;
electrical c109;
electrical c110;
electrical c111;
electrical c112;
electrical c113;
electrical c114;
electrical c115;
electrical c116;
electrical c117;
electrical c118;
electrical c119;
electrical c120;
electrical c121;
electrical c122;
electrical c123;
electrical c124;
electrical c125;
electrical c126;
electrical c127;
electrical c128;
electrical c129;
electrical c130;
electrical c131;
electrical c132;
electrical c133;
electrical c134;
electrical c135;
electrical c136;
electrical c137;
electrical c138;
electrical c139;
electrical c140;
electrical c141;
electrical c142;
electrical c143;
electrical c144;
electrical c145;
electrical c146;
electrical c147;
electrical c148;
electrical c149;
electrical c150;
electrical c151;
electrical c152;
electrical c153;
electrical c154;
electrical c155;
electrical c156;
electrical c157;
electrical c158;
electrical c159;
electrical c160;
electrical c161;
electrical c162;
electrical c163;
electrical c164;
electrical c165;
electrical c166;
electrical c167;
electrical c168;
electrical c169;
electrical c170;
electrical c171;
electrical c172;
electrical c173;
electrical c174;
electrical c175;
electrical c176;
electrical c177;
electrical c178;
electrical c179;
electrical c180;
electrical c181;
electrical c182;
electrical c183;
electrical c184;
electrical c185;
electrical c186;
electrical c187;
electrical c188;
electrical c189;
electrical c190;
electrical c191;
electrical c192;
electrical c193;
electrical c194;
electrical c195;
electrical c196;
electrical c197;
electrical c198;
electrical c199;
electrical c200;
electrical c201;
electrical c202;
electrical c203;
electrical c204;
electrical c205;
electrical c206;
electrical c207;
electrical c208;
electrical c209;
electrical c210;
electrical c211;
electrical c212;
electrical c213;
electrical c214;
electrical c215;
electrical c216;
electrical c217;
electrical c218;
electrical c219;
electrical c220;
electrical c221;
electrical c222;
electrical c223;
electrical c224;
electrical c225;
electrical c226;
electrical c227;
electrical c228;
electrical c229;
electrical c230;
electrical c231;
electrical c232;
electrical c233;
electrical c234;
electrical c235;
electrical c236;
electrical c237;
electrical c238;
electrical c239;
electrical c240;
electrical c241;
electrical c242;
electrical c243;
electrical c244;
electrical c245;
electrical c246;
electrical c247;
electrical c248;
electrical c249;
electrical c250;
electrical c251;
electrical c252;
electrical c253;
electrical c254;
electrical c255;
electrical c256;
electrical c257;
electrical c258;
electrical c259;
electrical c260;
electrical c261;
electrical c262;
electrical c263;
electrical c264;
electrical c265;
electrical c266;
electrical c267;
electrical c268;
electrical c269;
electrical c270;
electrical c271;
electrical c272;
electrical c273;
electrical c274;
electrical c275;
electrical c276;
electrical c277;
electrical c278;
electrical c279;
electrical c280;
electrical c281;
electrical c282;
electrical c283;
electrical c284;
electrical c285;
electrical c286;
electrical c287;
electrical c288;
electrical c289;
electrical c290;
electrical c291;
electrical c292;
electrical c293;
electrical c294;
electrical c295;
electrical c296;
electrical c297;
electrical c298;
electrical c299;
electrical c300;
electrical c301;
electrical c302;
electrical c303;
electrical c304;
electrical c305;
electrical c306;
electrical c307;
electrical c308;
electrical c309;
electrical c310;
electrical c311;
electrical c312;
electrical c313;
electrical c314;
electrical c315;
electrical c316;
electrical c317;
electrical c318;
electrical c319;
electrical c320;
electrical c321;
electrical c322;
electrical c323;
electrical c324;
electrical c325;
electrical c326;
electrical c327;
electrical c328;
electrical c329;
electrical c330;
electrical c331;
electrical c332;
electrical c333;
electrical c334;
electrical c335;
electrical c336;
electrical c337;
electrical c338;
electrical c339;
electrical c340;
electrical c341;
electrical c342;
electrical c343;
electrical c344;
electrical c345;
electrical c346;
electrical c347;
electrical c348;
electrical c349;
electrical c350;
electrical c351;
electrical c352;
electrical c353;
electrical c354;
electrical c355;
electrical c356;
electrical c357;
electrical c358;
electrical c359;
electrical c360;
electrical c361;
electrical c362;
electrical c363;
electrical c364;
electrical c365;
electrical c366;
electrical c367;
electrical c368;
electrical c369;
electrical c370;
electrical c371;
electrical c372;
electrical c373;
electrical c374;
electrical c375;
electrical c376;
electrical c377;
electrical c378;
electrical c379;
electrical c380;
electrical c381;
electrical c382;
electrical c383;
electrical c384;
electrical c385;
electrical c386;
electrical c387;
electrical c388;
electrical c389;
electrical c390;
electrical c391;
electrical c392;
electrical c393;
electrical c394;
electrical c395;
electrical c396;
electrical c397;
electrical c398;
electrical c399;
electrical c400;
electrical c401;
electrical c402;
electrical c403;
electrical c404;
electrical c405;
electrical c406;
electrical c407;
electrical c408;
electrical c409;
electrical c410;
electrical c411;
electrical c412;
electrical c413;
electrical c414;
electrical c415;
electrical c416;
electrical c417;
electrical c418;
electrical c419;
electrical c420;
electrical c421;
electrical c422;
electrical c423;
electrical c424;
electrical c425;
electrical c426;
electrical c427;
electrical c428;
electrical c429;
electrical c430;
electrical c431;
electrical c432;
electrical c433;
electrical c434;
electrical c435;
electrical c436;
electrical c437;
electrical c438;
electrical c439;
electrical c440;
electrical c441;
electrical c442;
electrical c443;
electrical c444;
electrical c445;
electrical c446;
electrical c447;
electrical c448;
electrical c449;
electrical c450;
electrical c451;
electrical c452;
electrical c453;
electrical c454;
electrical c455;
electrical c456;
electrical c457;
electrical c458;
electrical c459;
electrical c460;
electrical c461;
electrical c462;
electrical c463;
electrical c464;
electrical c465;
electrical c466;
electrical c467;
electrical c468;
electrical c469;
electrical c470;
electrical c471;
electrical c472;
electrical c473;
electrical c474;
electrical c475;
electrical c476;
electrical c477;
electrical c478;
electrical c479;
electrical c480;
electrical c481;
electrical c482;
electrical c483;
electrical c484;
electrical c485;
electrical c486;
electrical c487;
electrical c488;
electrical c489;
electrical c490;
electrical c491;
electrical c492;
electrical c493;
electrical c494;
electrical c495;
electrical c496;
electrical c497;
electrical c498;
electrical c499;
electrical c500;
electrical c501;
electrical c502;
electrical c503;
electrical c504;
electrical c505;
electrical c506;
electrical c507;
electrical c508;
electrical c509;
electrical c510;

parameter real fout  = 6.2e9;
parameter real fref  = 76.8e6;
parameter real frac2 = 0.458333;
parameter real Tres  = 390e-15;   // 晶体管 DTC 实测单位步长 (fingers=15 单元)
parameter real vth   = 0.4;

real tdel, code_tot;
integer code;
analog begin
    @(initial_step) begin code = 0; code_tot = 200.0; end
    @(cross(V(ckfb) - vth, +1)) begin
        tdel = V(kdtc)*(V(epsc) - (0.5 - frac2))*(0.5/fout)
             + V(sel)*V(vdcc)*1e-12 + V(alt)*V(rdcc)*1e-12;
        code = (tdel >= 0.0) ? floor(tdel/Tres + 0.5) : ceil(tdel/Tres - 0.5);
        if (code > 255) code = 255;
        if (code < -255) code = -255;
        code_tot = code + 200.0;
    end
    V(c0) <+ (code_tot > 0) ? 0.8 : 0.0;
    V(c1) <+ (code_tot > 1) ? 0.8 : 0.0;
    V(c2) <+ (code_tot > 2) ? 0.8 : 0.0;
    V(c3) <+ (code_tot > 3) ? 0.8 : 0.0;
    V(c4) <+ (code_tot > 4) ? 0.8 : 0.0;
    V(c5) <+ (code_tot > 5) ? 0.8 : 0.0;
    V(c6) <+ (code_tot > 6) ? 0.8 : 0.0;
    V(c7) <+ (code_tot > 7) ? 0.8 : 0.0;
    V(c8) <+ (code_tot > 8) ? 0.8 : 0.0;
    V(c9) <+ (code_tot > 9) ? 0.8 : 0.0;
    V(c10) <+ (code_tot > 10) ? 0.8 : 0.0;
    V(c11) <+ (code_tot > 11) ? 0.8 : 0.0;
    V(c12) <+ (code_tot > 12) ? 0.8 : 0.0;
    V(c13) <+ (code_tot > 13) ? 0.8 : 0.0;
    V(c14) <+ (code_tot > 14) ? 0.8 : 0.0;
    V(c15) <+ (code_tot > 15) ? 0.8 : 0.0;
    V(c16) <+ (code_tot > 16) ? 0.8 : 0.0;
    V(c17) <+ (code_tot > 17) ? 0.8 : 0.0;
    V(c18) <+ (code_tot > 18) ? 0.8 : 0.0;
    V(c19) <+ (code_tot > 19) ? 0.8 : 0.0;
    V(c20) <+ (code_tot > 20) ? 0.8 : 0.0;
    V(c21) <+ (code_tot > 21) ? 0.8 : 0.0;
    V(c22) <+ (code_tot > 22) ? 0.8 : 0.0;
    V(c23) <+ (code_tot > 23) ? 0.8 : 0.0;
    V(c24) <+ (code_tot > 24) ? 0.8 : 0.0;
    V(c25) <+ (code_tot > 25) ? 0.8 : 0.0;
    V(c26) <+ (code_tot > 26) ? 0.8 : 0.0;
    V(c27) <+ (code_tot > 27) ? 0.8 : 0.0;
    V(c28) <+ (code_tot > 28) ? 0.8 : 0.0;
    V(c29) <+ (code_tot > 29) ? 0.8 : 0.0;
    V(c30) <+ (code_tot > 30) ? 0.8 : 0.0;
    V(c31) <+ (code_tot > 31) ? 0.8 : 0.0;
    V(c32) <+ (code_tot > 32) ? 0.8 : 0.0;
    V(c33) <+ (code_tot > 33) ? 0.8 : 0.0;
    V(c34) <+ (code_tot > 34) ? 0.8 : 0.0;
    V(c35) <+ (code_tot > 35) ? 0.8 : 0.0;
    V(c36) <+ (code_tot > 36) ? 0.8 : 0.0;
    V(c37) <+ (code_tot > 37) ? 0.8 : 0.0;
    V(c38) <+ (code_tot > 38) ? 0.8 : 0.0;
    V(c39) <+ (code_tot > 39) ? 0.8 : 0.0;
    V(c40) <+ (code_tot > 40) ? 0.8 : 0.0;
    V(c41) <+ (code_tot > 41) ? 0.8 : 0.0;
    V(c42) <+ (code_tot > 42) ? 0.8 : 0.0;
    V(c43) <+ (code_tot > 43) ? 0.8 : 0.0;
    V(c44) <+ (code_tot > 44) ? 0.8 : 0.0;
    V(c45) <+ (code_tot > 45) ? 0.8 : 0.0;
    V(c46) <+ (code_tot > 46) ? 0.8 : 0.0;
    V(c47) <+ (code_tot > 47) ? 0.8 : 0.0;
    V(c48) <+ (code_tot > 48) ? 0.8 : 0.0;
    V(c49) <+ (code_tot > 49) ? 0.8 : 0.0;
    V(c50) <+ (code_tot > 50) ? 0.8 : 0.0;
    V(c51) <+ (code_tot > 51) ? 0.8 : 0.0;
    V(c52) <+ (code_tot > 52) ? 0.8 : 0.0;
    V(c53) <+ (code_tot > 53) ? 0.8 : 0.0;
    V(c54) <+ (code_tot > 54) ? 0.8 : 0.0;
    V(c55) <+ (code_tot > 55) ? 0.8 : 0.0;
    V(c56) <+ (code_tot > 56) ? 0.8 : 0.0;
    V(c57) <+ (code_tot > 57) ? 0.8 : 0.0;
    V(c58) <+ (code_tot > 58) ? 0.8 : 0.0;
    V(c59) <+ (code_tot > 59) ? 0.8 : 0.0;
    V(c60) <+ (code_tot > 60) ? 0.8 : 0.0;
    V(c61) <+ (code_tot > 61) ? 0.8 : 0.0;
    V(c62) <+ (code_tot > 62) ? 0.8 : 0.0;
    V(c63) <+ (code_tot > 63) ? 0.8 : 0.0;
    V(c64) <+ (code_tot > 64) ? 0.8 : 0.0;
    V(c65) <+ (code_tot > 65) ? 0.8 : 0.0;
    V(c66) <+ (code_tot > 66) ? 0.8 : 0.0;
    V(c67) <+ (code_tot > 67) ? 0.8 : 0.0;
    V(c68) <+ (code_tot > 68) ? 0.8 : 0.0;
    V(c69) <+ (code_tot > 69) ? 0.8 : 0.0;
    V(c70) <+ (code_tot > 70) ? 0.8 : 0.0;
    V(c71) <+ (code_tot > 71) ? 0.8 : 0.0;
    V(c72) <+ (code_tot > 72) ? 0.8 : 0.0;
    V(c73) <+ (code_tot > 73) ? 0.8 : 0.0;
    V(c74) <+ (code_tot > 74) ? 0.8 : 0.0;
    V(c75) <+ (code_tot > 75) ? 0.8 : 0.0;
    V(c76) <+ (code_tot > 76) ? 0.8 : 0.0;
    V(c77) <+ (code_tot > 77) ? 0.8 : 0.0;
    V(c78) <+ (code_tot > 78) ? 0.8 : 0.0;
    V(c79) <+ (code_tot > 79) ? 0.8 : 0.0;
    V(c80) <+ (code_tot > 80) ? 0.8 : 0.0;
    V(c81) <+ (code_tot > 81) ? 0.8 : 0.0;
    V(c82) <+ (code_tot > 82) ? 0.8 : 0.0;
    V(c83) <+ (code_tot > 83) ? 0.8 : 0.0;
    V(c84) <+ (code_tot > 84) ? 0.8 : 0.0;
    V(c85) <+ (code_tot > 85) ? 0.8 : 0.0;
    V(c86) <+ (code_tot > 86) ? 0.8 : 0.0;
    V(c87) <+ (code_tot > 87) ? 0.8 : 0.0;
    V(c88) <+ (code_tot > 88) ? 0.8 : 0.0;
    V(c89) <+ (code_tot > 89) ? 0.8 : 0.0;
    V(c90) <+ (code_tot > 90) ? 0.8 : 0.0;
    V(c91) <+ (code_tot > 91) ? 0.8 : 0.0;
    V(c92) <+ (code_tot > 92) ? 0.8 : 0.0;
    V(c93) <+ (code_tot > 93) ? 0.8 : 0.0;
    V(c94) <+ (code_tot > 94) ? 0.8 : 0.0;
    V(c95) <+ (code_tot > 95) ? 0.8 : 0.0;
    V(c96) <+ (code_tot > 96) ? 0.8 : 0.0;
    V(c97) <+ (code_tot > 97) ? 0.8 : 0.0;
    V(c98) <+ (code_tot > 98) ? 0.8 : 0.0;
    V(c99) <+ (code_tot > 99) ? 0.8 : 0.0;
    V(c100) <+ (code_tot > 100) ? 0.8 : 0.0;
    V(c101) <+ (code_tot > 101) ? 0.8 : 0.0;
    V(c102) <+ (code_tot > 102) ? 0.8 : 0.0;
    V(c103) <+ (code_tot > 103) ? 0.8 : 0.0;
    V(c104) <+ (code_tot > 104) ? 0.8 : 0.0;
    V(c105) <+ (code_tot > 105) ? 0.8 : 0.0;
    V(c106) <+ (code_tot > 106) ? 0.8 : 0.0;
    V(c107) <+ (code_tot > 107) ? 0.8 : 0.0;
    V(c108) <+ (code_tot > 108) ? 0.8 : 0.0;
    V(c109) <+ (code_tot > 109) ? 0.8 : 0.0;
    V(c110) <+ (code_tot > 110) ? 0.8 : 0.0;
    V(c111) <+ (code_tot > 111) ? 0.8 : 0.0;
    V(c112) <+ (code_tot > 112) ? 0.8 : 0.0;
    V(c113) <+ (code_tot > 113) ? 0.8 : 0.0;
    V(c114) <+ (code_tot > 114) ? 0.8 : 0.0;
    V(c115) <+ (code_tot > 115) ? 0.8 : 0.0;
    V(c116) <+ (code_tot > 116) ? 0.8 : 0.0;
    V(c117) <+ (code_tot > 117) ? 0.8 : 0.0;
    V(c118) <+ (code_tot > 118) ? 0.8 : 0.0;
    V(c119) <+ (code_tot > 119) ? 0.8 : 0.0;
    V(c120) <+ (code_tot > 120) ? 0.8 : 0.0;
    V(c121) <+ (code_tot > 121) ? 0.8 : 0.0;
    V(c122) <+ (code_tot > 122) ? 0.8 : 0.0;
    V(c123) <+ (code_tot > 123) ? 0.8 : 0.0;
    V(c124) <+ (code_tot > 124) ? 0.8 : 0.0;
    V(c125) <+ (code_tot > 125) ? 0.8 : 0.0;
    V(c126) <+ (code_tot > 126) ? 0.8 : 0.0;
    V(c127) <+ (code_tot > 127) ? 0.8 : 0.0;
    V(c128) <+ (code_tot > 128) ? 0.8 : 0.0;
    V(c129) <+ (code_tot > 129) ? 0.8 : 0.0;
    V(c130) <+ (code_tot > 130) ? 0.8 : 0.0;
    V(c131) <+ (code_tot > 131) ? 0.8 : 0.0;
    V(c132) <+ (code_tot > 132) ? 0.8 : 0.0;
    V(c133) <+ (code_tot > 133) ? 0.8 : 0.0;
    V(c134) <+ (code_tot > 134) ? 0.8 : 0.0;
    V(c135) <+ (code_tot > 135) ? 0.8 : 0.0;
    V(c136) <+ (code_tot > 136) ? 0.8 : 0.0;
    V(c137) <+ (code_tot > 137) ? 0.8 : 0.0;
    V(c138) <+ (code_tot > 138) ? 0.8 : 0.0;
    V(c139) <+ (code_tot > 139) ? 0.8 : 0.0;
    V(c140) <+ (code_tot > 140) ? 0.8 : 0.0;
    V(c141) <+ (code_tot > 141) ? 0.8 : 0.0;
    V(c142) <+ (code_tot > 142) ? 0.8 : 0.0;
    V(c143) <+ (code_tot > 143) ? 0.8 : 0.0;
    V(c144) <+ (code_tot > 144) ? 0.8 : 0.0;
    V(c145) <+ (code_tot > 145) ? 0.8 : 0.0;
    V(c146) <+ (code_tot > 146) ? 0.8 : 0.0;
    V(c147) <+ (code_tot > 147) ? 0.8 : 0.0;
    V(c148) <+ (code_tot > 148) ? 0.8 : 0.0;
    V(c149) <+ (code_tot > 149) ? 0.8 : 0.0;
    V(c150) <+ (code_tot > 150) ? 0.8 : 0.0;
    V(c151) <+ (code_tot > 151) ? 0.8 : 0.0;
    V(c152) <+ (code_tot > 152) ? 0.8 : 0.0;
    V(c153) <+ (code_tot > 153) ? 0.8 : 0.0;
    V(c154) <+ (code_tot > 154) ? 0.8 : 0.0;
    V(c155) <+ (code_tot > 155) ? 0.8 : 0.0;
    V(c156) <+ (code_tot > 156) ? 0.8 : 0.0;
    V(c157) <+ (code_tot > 157) ? 0.8 : 0.0;
    V(c158) <+ (code_tot > 158) ? 0.8 : 0.0;
    V(c159) <+ (code_tot > 159) ? 0.8 : 0.0;
    V(c160) <+ (code_tot > 160) ? 0.8 : 0.0;
    V(c161) <+ (code_tot > 161) ? 0.8 : 0.0;
    V(c162) <+ (code_tot > 162) ? 0.8 : 0.0;
    V(c163) <+ (code_tot > 163) ? 0.8 : 0.0;
    V(c164) <+ (code_tot > 164) ? 0.8 : 0.0;
    V(c165) <+ (code_tot > 165) ? 0.8 : 0.0;
    V(c166) <+ (code_tot > 166) ? 0.8 : 0.0;
    V(c167) <+ (code_tot > 167) ? 0.8 : 0.0;
    V(c168) <+ (code_tot > 168) ? 0.8 : 0.0;
    V(c169) <+ (code_tot > 169) ? 0.8 : 0.0;
    V(c170) <+ (code_tot > 170) ? 0.8 : 0.0;
    V(c171) <+ (code_tot > 171) ? 0.8 : 0.0;
    V(c172) <+ (code_tot > 172) ? 0.8 : 0.0;
    V(c173) <+ (code_tot > 173) ? 0.8 : 0.0;
    V(c174) <+ (code_tot > 174) ? 0.8 : 0.0;
    V(c175) <+ (code_tot > 175) ? 0.8 : 0.0;
    V(c176) <+ (code_tot > 176) ? 0.8 : 0.0;
    V(c177) <+ (code_tot > 177) ? 0.8 : 0.0;
    V(c178) <+ (code_tot > 178) ? 0.8 : 0.0;
    V(c179) <+ (code_tot > 179) ? 0.8 : 0.0;
    V(c180) <+ (code_tot > 180) ? 0.8 : 0.0;
    V(c181) <+ (code_tot > 181) ? 0.8 : 0.0;
    V(c182) <+ (code_tot > 182) ? 0.8 : 0.0;
    V(c183) <+ (code_tot > 183) ? 0.8 : 0.0;
    V(c184) <+ (code_tot > 184) ? 0.8 : 0.0;
    V(c185) <+ (code_tot > 185) ? 0.8 : 0.0;
    V(c186) <+ (code_tot > 186) ? 0.8 : 0.0;
    V(c187) <+ (code_tot > 187) ? 0.8 : 0.0;
    V(c188) <+ (code_tot > 188) ? 0.8 : 0.0;
    V(c189) <+ (code_tot > 189) ? 0.8 : 0.0;
    V(c190) <+ (code_tot > 190) ? 0.8 : 0.0;
    V(c191) <+ (code_tot > 191) ? 0.8 : 0.0;
    V(c192) <+ (code_tot > 192) ? 0.8 : 0.0;
    V(c193) <+ (code_tot > 193) ? 0.8 : 0.0;
    V(c194) <+ (code_tot > 194) ? 0.8 : 0.0;
    V(c195) <+ (code_tot > 195) ? 0.8 : 0.0;
    V(c196) <+ (code_tot > 196) ? 0.8 : 0.0;
    V(c197) <+ (code_tot > 197) ? 0.8 : 0.0;
    V(c198) <+ (code_tot > 198) ? 0.8 : 0.0;
    V(c199) <+ (code_tot > 199) ? 0.8 : 0.0;
    V(c200) <+ (code_tot > 200) ? 0.8 : 0.0;
    V(c201) <+ (code_tot > 201) ? 0.8 : 0.0;
    V(c202) <+ (code_tot > 202) ? 0.8 : 0.0;
    V(c203) <+ (code_tot > 203) ? 0.8 : 0.0;
    V(c204) <+ (code_tot > 204) ? 0.8 : 0.0;
    V(c205) <+ (code_tot > 205) ? 0.8 : 0.0;
    V(c206) <+ (code_tot > 206) ? 0.8 : 0.0;
    V(c207) <+ (code_tot > 207) ? 0.8 : 0.0;
    V(c208) <+ (code_tot > 208) ? 0.8 : 0.0;
    V(c209) <+ (code_tot > 209) ? 0.8 : 0.0;
    V(c210) <+ (code_tot > 210) ? 0.8 : 0.0;
    V(c211) <+ (code_tot > 211) ? 0.8 : 0.0;
    V(c212) <+ (code_tot > 212) ? 0.8 : 0.0;
    V(c213) <+ (code_tot > 213) ? 0.8 : 0.0;
    V(c214) <+ (code_tot > 214) ? 0.8 : 0.0;
    V(c215) <+ (code_tot > 215) ? 0.8 : 0.0;
    V(c216) <+ (code_tot > 216) ? 0.8 : 0.0;
    V(c217) <+ (code_tot > 217) ? 0.8 : 0.0;
    V(c218) <+ (code_tot > 218) ? 0.8 : 0.0;
    V(c219) <+ (code_tot > 219) ? 0.8 : 0.0;
    V(c220) <+ (code_tot > 220) ? 0.8 : 0.0;
    V(c221) <+ (code_tot > 221) ? 0.8 : 0.0;
    V(c222) <+ (code_tot > 222) ? 0.8 : 0.0;
    V(c223) <+ (code_tot > 223) ? 0.8 : 0.0;
    V(c224) <+ (code_tot > 224) ? 0.8 : 0.0;
    V(c225) <+ (code_tot > 225) ? 0.8 : 0.0;
    V(c226) <+ (code_tot > 226) ? 0.8 : 0.0;
    V(c227) <+ (code_tot > 227) ? 0.8 : 0.0;
    V(c228) <+ (code_tot > 228) ? 0.8 : 0.0;
    V(c229) <+ (code_tot > 229) ? 0.8 : 0.0;
    V(c230) <+ (code_tot > 230) ? 0.8 : 0.0;
    V(c231) <+ (code_tot > 231) ? 0.8 : 0.0;
    V(c232) <+ (code_tot > 232) ? 0.8 : 0.0;
    V(c233) <+ (code_tot > 233) ? 0.8 : 0.0;
    V(c234) <+ (code_tot > 234) ? 0.8 : 0.0;
    V(c235) <+ (code_tot > 235) ? 0.8 : 0.0;
    V(c236) <+ (code_tot > 236) ? 0.8 : 0.0;
    V(c237) <+ (code_tot > 237) ? 0.8 : 0.0;
    V(c238) <+ (code_tot > 238) ? 0.8 : 0.0;
    V(c239) <+ (code_tot > 239) ? 0.8 : 0.0;
    V(c240) <+ (code_tot > 240) ? 0.8 : 0.0;
    V(c241) <+ (code_tot > 241) ? 0.8 : 0.0;
    V(c242) <+ (code_tot > 242) ? 0.8 : 0.0;
    V(c243) <+ (code_tot > 243) ? 0.8 : 0.0;
    V(c244) <+ (code_tot > 244) ? 0.8 : 0.0;
    V(c245) <+ (code_tot > 245) ? 0.8 : 0.0;
    V(c246) <+ (code_tot > 246) ? 0.8 : 0.0;
    V(c247) <+ (code_tot > 247) ? 0.8 : 0.0;
    V(c248) <+ (code_tot > 248) ? 0.8 : 0.0;
    V(c249) <+ (code_tot > 249) ? 0.8 : 0.0;
    V(c250) <+ (code_tot > 250) ? 0.8 : 0.0;
    V(c251) <+ (code_tot > 251) ? 0.8 : 0.0;
    V(c252) <+ (code_tot > 252) ? 0.8 : 0.0;
    V(c253) <+ (code_tot > 253) ? 0.8 : 0.0;
    V(c254) <+ (code_tot > 254) ? 0.8 : 0.0;
    V(c255) <+ (code_tot > 255) ? 0.8 : 0.0;
    V(c256) <+ (code_tot > 256) ? 0.8 : 0.0;
    V(c257) <+ (code_tot > 257) ? 0.8 : 0.0;
    V(c258) <+ (code_tot > 258) ? 0.8 : 0.0;
    V(c259) <+ (code_tot > 259) ? 0.8 : 0.0;
    V(c260) <+ (code_tot > 260) ? 0.8 : 0.0;
    V(c261) <+ (code_tot > 261) ? 0.8 : 0.0;
    V(c262) <+ (code_tot > 262) ? 0.8 : 0.0;
    V(c263) <+ (code_tot > 263) ? 0.8 : 0.0;
    V(c264) <+ (code_tot > 264) ? 0.8 : 0.0;
    V(c265) <+ (code_tot > 265) ? 0.8 : 0.0;
    V(c266) <+ (code_tot > 266) ? 0.8 : 0.0;
    V(c267) <+ (code_tot > 267) ? 0.8 : 0.0;
    V(c268) <+ (code_tot > 268) ? 0.8 : 0.0;
    V(c269) <+ (code_tot > 269) ? 0.8 : 0.0;
    V(c270) <+ (code_tot > 270) ? 0.8 : 0.0;
    V(c271) <+ (code_tot > 271) ? 0.8 : 0.0;
    V(c272) <+ (code_tot > 272) ? 0.8 : 0.0;
    V(c273) <+ (code_tot > 273) ? 0.8 : 0.0;
    V(c274) <+ (code_tot > 274) ? 0.8 : 0.0;
    V(c275) <+ (code_tot > 275) ? 0.8 : 0.0;
    V(c276) <+ (code_tot > 276) ? 0.8 : 0.0;
    V(c277) <+ (code_tot > 277) ? 0.8 : 0.0;
    V(c278) <+ (code_tot > 278) ? 0.8 : 0.0;
    V(c279) <+ (code_tot > 279) ? 0.8 : 0.0;
    V(c280) <+ (code_tot > 280) ? 0.8 : 0.0;
    V(c281) <+ (code_tot > 281) ? 0.8 : 0.0;
    V(c282) <+ (code_tot > 282) ? 0.8 : 0.0;
    V(c283) <+ (code_tot > 283) ? 0.8 : 0.0;
    V(c284) <+ (code_tot > 284) ? 0.8 : 0.0;
    V(c285) <+ (code_tot > 285) ? 0.8 : 0.0;
    V(c286) <+ (code_tot > 286) ? 0.8 : 0.0;
    V(c287) <+ (code_tot > 287) ? 0.8 : 0.0;
    V(c288) <+ (code_tot > 288) ? 0.8 : 0.0;
    V(c289) <+ (code_tot > 289) ? 0.8 : 0.0;
    V(c290) <+ (code_tot > 290) ? 0.8 : 0.0;
    V(c291) <+ (code_tot > 291) ? 0.8 : 0.0;
    V(c292) <+ (code_tot > 292) ? 0.8 : 0.0;
    V(c293) <+ (code_tot > 293) ? 0.8 : 0.0;
    V(c294) <+ (code_tot > 294) ? 0.8 : 0.0;
    V(c295) <+ (code_tot > 295) ? 0.8 : 0.0;
    V(c296) <+ (code_tot > 296) ? 0.8 : 0.0;
    V(c297) <+ (code_tot > 297) ? 0.8 : 0.0;
    V(c298) <+ (code_tot > 298) ? 0.8 : 0.0;
    V(c299) <+ (code_tot > 299) ? 0.8 : 0.0;
    V(c300) <+ (code_tot > 300) ? 0.8 : 0.0;
    V(c301) <+ (code_tot > 301) ? 0.8 : 0.0;
    V(c302) <+ (code_tot > 302) ? 0.8 : 0.0;
    V(c303) <+ (code_tot > 303) ? 0.8 : 0.0;
    V(c304) <+ (code_tot > 304) ? 0.8 : 0.0;
    V(c305) <+ (code_tot > 305) ? 0.8 : 0.0;
    V(c306) <+ (code_tot > 306) ? 0.8 : 0.0;
    V(c307) <+ (code_tot > 307) ? 0.8 : 0.0;
    V(c308) <+ (code_tot > 308) ? 0.8 : 0.0;
    V(c309) <+ (code_tot > 309) ? 0.8 : 0.0;
    V(c310) <+ (code_tot > 310) ? 0.8 : 0.0;
    V(c311) <+ (code_tot > 311) ? 0.8 : 0.0;
    V(c312) <+ (code_tot > 312) ? 0.8 : 0.0;
    V(c313) <+ (code_tot > 313) ? 0.8 : 0.0;
    V(c314) <+ (code_tot > 314) ? 0.8 : 0.0;
    V(c315) <+ (code_tot > 315) ? 0.8 : 0.0;
    V(c316) <+ (code_tot > 316) ? 0.8 : 0.0;
    V(c317) <+ (code_tot > 317) ? 0.8 : 0.0;
    V(c318) <+ (code_tot > 318) ? 0.8 : 0.0;
    V(c319) <+ (code_tot > 319) ? 0.8 : 0.0;
    V(c320) <+ (code_tot > 320) ? 0.8 : 0.0;
    V(c321) <+ (code_tot > 321) ? 0.8 : 0.0;
    V(c322) <+ (code_tot > 322) ? 0.8 : 0.0;
    V(c323) <+ (code_tot > 323) ? 0.8 : 0.0;
    V(c324) <+ (code_tot > 324) ? 0.8 : 0.0;
    V(c325) <+ (code_tot > 325) ? 0.8 : 0.0;
    V(c326) <+ (code_tot > 326) ? 0.8 : 0.0;
    V(c327) <+ (code_tot > 327) ? 0.8 : 0.0;
    V(c328) <+ (code_tot > 328) ? 0.8 : 0.0;
    V(c329) <+ (code_tot > 329) ? 0.8 : 0.0;
    V(c330) <+ (code_tot > 330) ? 0.8 : 0.0;
    V(c331) <+ (code_tot > 331) ? 0.8 : 0.0;
    V(c332) <+ (code_tot > 332) ? 0.8 : 0.0;
    V(c333) <+ (code_tot > 333) ? 0.8 : 0.0;
    V(c334) <+ (code_tot > 334) ? 0.8 : 0.0;
    V(c335) <+ (code_tot > 335) ? 0.8 : 0.0;
    V(c336) <+ (code_tot > 336) ? 0.8 : 0.0;
    V(c337) <+ (code_tot > 337) ? 0.8 : 0.0;
    V(c338) <+ (code_tot > 338) ? 0.8 : 0.0;
    V(c339) <+ (code_tot > 339) ? 0.8 : 0.0;
    V(c340) <+ (code_tot > 340) ? 0.8 : 0.0;
    V(c341) <+ (code_tot > 341) ? 0.8 : 0.0;
    V(c342) <+ (code_tot > 342) ? 0.8 : 0.0;
    V(c343) <+ (code_tot > 343) ? 0.8 : 0.0;
    V(c344) <+ (code_tot > 344) ? 0.8 : 0.0;
    V(c345) <+ (code_tot > 345) ? 0.8 : 0.0;
    V(c346) <+ (code_tot > 346) ? 0.8 : 0.0;
    V(c347) <+ (code_tot > 347) ? 0.8 : 0.0;
    V(c348) <+ (code_tot > 348) ? 0.8 : 0.0;
    V(c349) <+ (code_tot > 349) ? 0.8 : 0.0;
    V(c350) <+ (code_tot > 350) ? 0.8 : 0.0;
    V(c351) <+ (code_tot > 351) ? 0.8 : 0.0;
    V(c352) <+ (code_tot > 352) ? 0.8 : 0.0;
    V(c353) <+ (code_tot > 353) ? 0.8 : 0.0;
    V(c354) <+ (code_tot > 354) ? 0.8 : 0.0;
    V(c355) <+ (code_tot > 355) ? 0.8 : 0.0;
    V(c356) <+ (code_tot > 356) ? 0.8 : 0.0;
    V(c357) <+ (code_tot > 357) ? 0.8 : 0.0;
    V(c358) <+ (code_tot > 358) ? 0.8 : 0.0;
    V(c359) <+ (code_tot > 359) ? 0.8 : 0.0;
    V(c360) <+ (code_tot > 360) ? 0.8 : 0.0;
    V(c361) <+ (code_tot > 361) ? 0.8 : 0.0;
    V(c362) <+ (code_tot > 362) ? 0.8 : 0.0;
    V(c363) <+ (code_tot > 363) ? 0.8 : 0.0;
    V(c364) <+ (code_tot > 364) ? 0.8 : 0.0;
    V(c365) <+ (code_tot > 365) ? 0.8 : 0.0;
    V(c366) <+ (code_tot > 366) ? 0.8 : 0.0;
    V(c367) <+ (code_tot > 367) ? 0.8 : 0.0;
    V(c368) <+ (code_tot > 368) ? 0.8 : 0.0;
    V(c369) <+ (code_tot > 369) ? 0.8 : 0.0;
    V(c370) <+ (code_tot > 370) ? 0.8 : 0.0;
    V(c371) <+ (code_tot > 371) ? 0.8 : 0.0;
    V(c372) <+ (code_tot > 372) ? 0.8 : 0.0;
    V(c373) <+ (code_tot > 373) ? 0.8 : 0.0;
    V(c374) <+ (code_tot > 374) ? 0.8 : 0.0;
    V(c375) <+ (code_tot > 375) ? 0.8 : 0.0;
    V(c376) <+ (code_tot > 376) ? 0.8 : 0.0;
    V(c377) <+ (code_tot > 377) ? 0.8 : 0.0;
    V(c378) <+ (code_tot > 378) ? 0.8 : 0.0;
    V(c379) <+ (code_tot > 379) ? 0.8 : 0.0;
    V(c380) <+ (code_tot > 380) ? 0.8 : 0.0;
    V(c381) <+ (code_tot > 381) ? 0.8 : 0.0;
    V(c382) <+ (code_tot > 382) ? 0.8 : 0.0;
    V(c383) <+ (code_tot > 383) ? 0.8 : 0.0;
    V(c384) <+ (code_tot > 384) ? 0.8 : 0.0;
    V(c385) <+ (code_tot > 385) ? 0.8 : 0.0;
    V(c386) <+ (code_tot > 386) ? 0.8 : 0.0;
    V(c387) <+ (code_tot > 387) ? 0.8 : 0.0;
    V(c388) <+ (code_tot > 388) ? 0.8 : 0.0;
    V(c389) <+ (code_tot > 389) ? 0.8 : 0.0;
    V(c390) <+ (code_tot > 390) ? 0.8 : 0.0;
    V(c391) <+ (code_tot > 391) ? 0.8 : 0.0;
    V(c392) <+ (code_tot > 392) ? 0.8 : 0.0;
    V(c393) <+ (code_tot > 393) ? 0.8 : 0.0;
    V(c394) <+ (code_tot > 394) ? 0.8 : 0.0;
    V(c395) <+ (code_tot > 395) ? 0.8 : 0.0;
    V(c396) <+ (code_tot > 396) ? 0.8 : 0.0;
    V(c397) <+ (code_tot > 397) ? 0.8 : 0.0;
    V(c398) <+ (code_tot > 398) ? 0.8 : 0.0;
    V(c399) <+ (code_tot > 399) ? 0.8 : 0.0;
    V(c400) <+ (code_tot > 400) ? 0.8 : 0.0;
    V(c401) <+ (code_tot > 401) ? 0.8 : 0.0;
    V(c402) <+ (code_tot > 402) ? 0.8 : 0.0;
    V(c403) <+ (code_tot > 403) ? 0.8 : 0.0;
    V(c404) <+ (code_tot > 404) ? 0.8 : 0.0;
    V(c405) <+ (code_tot > 405) ? 0.8 : 0.0;
    V(c406) <+ (code_tot > 406) ? 0.8 : 0.0;
    V(c407) <+ (code_tot > 407) ? 0.8 : 0.0;
    V(c408) <+ (code_tot > 408) ? 0.8 : 0.0;
    V(c409) <+ (code_tot > 409) ? 0.8 : 0.0;
    V(c410) <+ (code_tot > 410) ? 0.8 : 0.0;
    V(c411) <+ (code_tot > 411) ? 0.8 : 0.0;
    V(c412) <+ (code_tot > 412) ? 0.8 : 0.0;
    V(c413) <+ (code_tot > 413) ? 0.8 : 0.0;
    V(c414) <+ (code_tot > 414) ? 0.8 : 0.0;
    V(c415) <+ (code_tot > 415) ? 0.8 : 0.0;
    V(c416) <+ (code_tot > 416) ? 0.8 : 0.0;
    V(c417) <+ (code_tot > 417) ? 0.8 : 0.0;
    V(c418) <+ (code_tot > 418) ? 0.8 : 0.0;
    V(c419) <+ (code_tot > 419) ? 0.8 : 0.0;
    V(c420) <+ (code_tot > 420) ? 0.8 : 0.0;
    V(c421) <+ (code_tot > 421) ? 0.8 : 0.0;
    V(c422) <+ (code_tot > 422) ? 0.8 : 0.0;
    V(c423) <+ (code_tot > 423) ? 0.8 : 0.0;
    V(c424) <+ (code_tot > 424) ? 0.8 : 0.0;
    V(c425) <+ (code_tot > 425) ? 0.8 : 0.0;
    V(c426) <+ (code_tot > 426) ? 0.8 : 0.0;
    V(c427) <+ (code_tot > 427) ? 0.8 : 0.0;
    V(c428) <+ (code_tot > 428) ? 0.8 : 0.0;
    V(c429) <+ (code_tot > 429) ? 0.8 : 0.0;
    V(c430) <+ (code_tot > 430) ? 0.8 : 0.0;
    V(c431) <+ (code_tot > 431) ? 0.8 : 0.0;
    V(c432) <+ (code_tot > 432) ? 0.8 : 0.0;
    V(c433) <+ (code_tot > 433) ? 0.8 : 0.0;
    V(c434) <+ (code_tot > 434) ? 0.8 : 0.0;
    V(c435) <+ (code_tot > 435) ? 0.8 : 0.0;
    V(c436) <+ (code_tot > 436) ? 0.8 : 0.0;
    V(c437) <+ (code_tot > 437) ? 0.8 : 0.0;
    V(c438) <+ (code_tot > 438) ? 0.8 : 0.0;
    V(c439) <+ (code_tot > 439) ? 0.8 : 0.0;
    V(c440) <+ (code_tot > 440) ? 0.8 : 0.0;
    V(c441) <+ (code_tot > 441) ? 0.8 : 0.0;
    V(c442) <+ (code_tot > 442) ? 0.8 : 0.0;
    V(c443) <+ (code_tot > 443) ? 0.8 : 0.0;
    V(c444) <+ (code_tot > 444) ? 0.8 : 0.0;
    V(c445) <+ (code_tot > 445) ? 0.8 : 0.0;
    V(c446) <+ (code_tot > 446) ? 0.8 : 0.0;
    V(c447) <+ (code_tot > 447) ? 0.8 : 0.0;
    V(c448) <+ (code_tot > 448) ? 0.8 : 0.0;
    V(c449) <+ (code_tot > 449) ? 0.8 : 0.0;
    V(c450) <+ (code_tot > 450) ? 0.8 : 0.0;
    V(c451) <+ (code_tot > 451) ? 0.8 : 0.0;
    V(c452) <+ (code_tot > 452) ? 0.8 : 0.0;
    V(c453) <+ (code_tot > 453) ? 0.8 : 0.0;
    V(c454) <+ (code_tot > 454) ? 0.8 : 0.0;
    V(c455) <+ (code_tot > 455) ? 0.8 : 0.0;
    V(c456) <+ (code_tot > 456) ? 0.8 : 0.0;
    V(c457) <+ (code_tot > 457) ? 0.8 : 0.0;
    V(c458) <+ (code_tot > 458) ? 0.8 : 0.0;
    V(c459) <+ (code_tot > 459) ? 0.8 : 0.0;
    V(c460) <+ (code_tot > 460) ? 0.8 : 0.0;
    V(c461) <+ (code_tot > 461) ? 0.8 : 0.0;
    V(c462) <+ (code_tot > 462) ? 0.8 : 0.0;
    V(c463) <+ (code_tot > 463) ? 0.8 : 0.0;
    V(c464) <+ (code_tot > 464) ? 0.8 : 0.0;
    V(c465) <+ (code_tot > 465) ? 0.8 : 0.0;
    V(c466) <+ (code_tot > 466) ? 0.8 : 0.0;
    V(c467) <+ (code_tot > 467) ? 0.8 : 0.0;
    V(c468) <+ (code_tot > 468) ? 0.8 : 0.0;
    V(c469) <+ (code_tot > 469) ? 0.8 : 0.0;
    V(c470) <+ (code_tot > 470) ? 0.8 : 0.0;
    V(c471) <+ (code_tot > 471) ? 0.8 : 0.0;
    V(c472) <+ (code_tot > 472) ? 0.8 : 0.0;
    V(c473) <+ (code_tot > 473) ? 0.8 : 0.0;
    V(c474) <+ (code_tot > 474) ? 0.8 : 0.0;
    V(c475) <+ (code_tot > 475) ? 0.8 : 0.0;
    V(c476) <+ (code_tot > 476) ? 0.8 : 0.0;
    V(c477) <+ (code_tot > 477) ? 0.8 : 0.0;
    V(c478) <+ (code_tot > 478) ? 0.8 : 0.0;
    V(c479) <+ (code_tot > 479) ? 0.8 : 0.0;
    V(c480) <+ (code_tot > 480) ? 0.8 : 0.0;
    V(c481) <+ (code_tot > 481) ? 0.8 : 0.0;
    V(c482) <+ (code_tot > 482) ? 0.8 : 0.0;
    V(c483) <+ (code_tot > 483) ? 0.8 : 0.0;
    V(c484) <+ (code_tot > 484) ? 0.8 : 0.0;
    V(c485) <+ (code_tot > 485) ? 0.8 : 0.0;
    V(c486) <+ (code_tot > 486) ? 0.8 : 0.0;
    V(c487) <+ (code_tot > 487) ? 0.8 : 0.0;
    V(c488) <+ (code_tot > 488) ? 0.8 : 0.0;
    V(c489) <+ (code_tot > 489) ? 0.8 : 0.0;
    V(c490) <+ (code_tot > 490) ? 0.8 : 0.0;
    V(c491) <+ (code_tot > 491) ? 0.8 : 0.0;
    V(c492) <+ (code_tot > 492) ? 0.8 : 0.0;
    V(c493) <+ (code_tot > 493) ? 0.8 : 0.0;
    V(c494) <+ (code_tot > 494) ? 0.8 : 0.0;
    V(c495) <+ (code_tot > 495) ? 0.8 : 0.0;
    V(c496) <+ (code_tot > 496) ? 0.8 : 0.0;
    V(c497) <+ (code_tot > 497) ? 0.8 : 0.0;
    V(c498) <+ (code_tot > 498) ? 0.8 : 0.0;
    V(c499) <+ (code_tot > 499) ? 0.8 : 0.0;
    V(c500) <+ (code_tot > 500) ? 0.8 : 0.0;
    V(c501) <+ (code_tot > 501) ? 0.8 : 0.0;
    V(c502) <+ (code_tot > 502) ? 0.8 : 0.0;
    V(c503) <+ (code_tot > 503) ? 0.8 : 0.0;
    V(c504) <+ (code_tot > 504) ? 0.8 : 0.0;
    V(c505) <+ (code_tot > 505) ? 0.8 : 0.0;
    V(c506) <+ (code_tot > 506) ? 0.8 : 0.0;
    V(c507) <+ (code_tot > 507) ? 0.8 : 0.0;
    V(c508) <+ (code_tot > 508) ? 0.8 : 0.0;
    V(c509) <+ (code_tot > 509) ? 0.8 : 0.0;
    V(c510) <+ (code_tot > 510) ? 0.8 : 0.0;
end
endmodule
