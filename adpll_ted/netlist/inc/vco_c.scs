// vco_c.scs — generated by tools/gen_vco_c.py (Plan C, paper Sec.IV)
// core supply VDDC=0.5V from LDO (ldo_05.scs); logic/enables on VDD=0.8V
// EN=0 -> bank group enabled (PMOS bulk switch on); EN=0.8 -> disabled
// varactor = direct moscap_rf (series-cap cell REJECTED: model pump)

// vco_x_c — Plan C core: 0.5V supply, Ls tail inductor, VAR banks
subckt vco_x_c (VDD VSS VCTRL_P VCTRL_I OUTP OUTN ENI0 ENI1 ENI2 \
    ENP0 ENP1 ENP2 ENP3 ENP4)
MN1 (OUTP OUTN TAIL VSS) nch_ulvt_mac l=16n nfin=2 w=58n multi=1 sd=74n sa=90n sb=90n ploda1=16n ploda2=0 ploda3=0 plodb1=16n plodb2=0 plodb3=0 nf_flag=1 smbt=1M smbb=1M dinsaflag=0 ppitch=0 spot=103n spob=103n spotl1=103n spobl1=103n spotl2=103n spobl2=103n spotr1=103n spobr1=103n spotr2=103n spobr2=103n nf=16
MN0 (OUTN OUTP TAIL VSS) nch_ulvt_mac l=16n nfin=2 w=58n multi=1 sd=74n sa=90n sb=90n ploda1=16n ploda2=0 ploda3=0 plodb1=16n plodb2=0 plodb3=0 nf_flag=1 smbt=1M smbb=1M dinsaflag=0 ppitch=0 spot=103n spob=103n spotl1=103n spobl1=103n spotl2=103n spobl2=103n spotr1=103n spobr1=103n spotr2=103n spobr2=103n nf=16
Ls (TAIL VSS) inductor l=2n r=1
L1 (VDD OUTN) inductor l=1.5n r=2
L0 (VDD OUTP) inductor l=1.5n r=2
Cbyp (VDD VSS) capacitor c=10p
CF0 (OUTP OUTN VSS) cfmom_wo_p80 dmflag=0 lr=1u multi=1 mxd_flag=0 nr=165 n_mxa=2 shield=2 spm=3 stm=1 vapmod=2 grflag=1 gdis_t=185n gdis_b=185n gdis_l=102n gdis_r=102n
CF1 (OUTN net01 VSS) cfmom_wo_p80 dmflag=0 lr=1u multi=1 mxd_flag=0 nr=165 n_mxa=2 shield=2 spm=3 stm=1 vapmod=2 grflag=1 gdis_t=185n gdis_b=185n gdis_l=102n gdis_r=102n
CF2 (OUTN net02 VSS) cfmom_wo_p80 dmflag=0 lr=1u multi=1 mxd_flag=0 nr=165 n_mxa=2 shield=2 spm=3 stm=1 vapmod=2 grflag=1 gdis_t=185n gdis_b=185n gdis_l=102n gdis_r=102n
CF3 (OUTN net03 VSS) cfmom_wo_p80 dmflag=0 lr=1u multi=1 mxd_flag=0 nr=165 n_mxa=2 shield=2 spm=3 stm=1 vapmod=2 grflag=1 gdis_t=185n gdis_b=185n gdis_l=102n gdis_r=102n
CF4 (OUTN net04 VSS) cfmom_wo_p80 dmflag=0 lr=1u multi=1 mxd_flag=0 nr=165 n_mxa=2 shield=2 spm=3 stm=1 vapmod=2 grflag=1 gdis_t=185n gdis_b=185n gdis_l=102n gdis_r=102n
CF5 (OUTN net05 VSS) cfmom_wo_p80 dmflag=0 lr=1u multi=1 mxd_flag=0 nr=165 n_mxa=2 shield=2 spm=3 stm=1 vapmod=2 grflag=1 gdis_t=185n gdis_b=185n gdis_l=102n gdis_r=102n
CF6 (OUTP OUTN VSS) cfmom_wo_p80 dmflag=0 lr=1u multi=1 mxd_flag=0 nr=165 n_mxa=2 shield=2 spm=3 stm=1 vapmod=2 grflag=1 gdis_t=185n gdis_b=185n gdis_l=102n gdis_r=102n
CF7 (OUTN net07 VSS) cfmom_wo_p80 dmflag=0 lr=1u multi=1 mxd_flag=0 nr=165 n_mxa=2 shield=2 spm=3 stm=1 vapmod=2 grflag=1 gdis_t=185n gdis_b=185n gdis_l=102n gdis_r=102n
CF8 (OUTN net08 VSS) cfmom_wo_p80 dmflag=0 lr=1u multi=1 mxd_flag=0 nr=165 n_mxa=2 shield=2 spm=3 stm=1 vapmod=2 grflag=1 gdis_t=185n gdis_b=185n gdis_l=102n gdis_r=102n
CF9 (OUTN net09 VSS) cfmom_wo_p80 dmflag=0 lr=1u multi=1 mxd_flag=0 nr=165 n_mxa=2 shield=2 spm=3 stm=1 vapmod=2 grflag=1 gdis_t=185n gdis_b=185n gdis_l=102n gdis_r=102n
CF10 (OUTN net10 VSS) cfmom_wo_p80 dmflag=0 lr=1u multi=1 mxd_flag=0 nr=165 n_mxa=2 shield=2 spm=3 stm=1 vapmod=2 grflag=1 gdis_t=185n gdis_b=185n gdis_l=102n gdis_r=102n
CF11 (OUTN net11 VSS) cfmom_wo_p80 dmflag=0 lr=1u multi=1 mxd_flag=0 nr=165 n_mxa=2 shield=2 spm=3 stm=1 vapmod=2 grflag=1 gdis_t=185n gdis_b=185n gdis_l=102n gdis_r=102n
VI00p_mv (OUTP VI00p_cb VI00p_cb) moscap_rf wr=538n lr=200n gr=2 br=2 multi=1 sobn=470n sobs=470n sobw=684n sobe=684n nfin=2
VI00p_sw (VCTRL_I ENI0 VI00p_cb VDD) pch_svt_mac l=16n nfin=2 w=58n multi=1 sd=74n sa=90n sb=90n ploda1=16n ploda2=0 ploda3=0 plodb1=16n plodb2=0 plodb3=0 nf_flag=1 smbt=1M smbb=1M dinsaflag=0 ppitch=0 spot=103n spob=103n spotl1=103n spobl1=103n spotl2=103n spobl2=103n spotr1=103n spobr1=103n spotr2=103n spobr2=103n nf=2
VI00p_rb (VI00p_cb VDD 0) resistor r=1M
VI00n_mv (OUTN VI00n_cb VI00n_cb) moscap_rf wr=538n lr=200n gr=2 br=2 multi=1 sobn=470n sobs=470n sobw=684n sobe=684n nfin=2
VI00n_sw (VCTRL_I ENI0 VI00n_cb VDD) pch_svt_mac l=16n nfin=2 w=58n multi=1 sd=74n sa=90n sb=90n ploda1=16n ploda2=0 ploda3=0 plodb1=16n plodb2=0 plodb3=0 nf_flag=1 smbt=1M smbb=1M dinsaflag=0 ppitch=0 spot=103n spob=103n spotl1=103n spobl1=103n spotl2=103n spobl2=103n spotr1=103n spobr1=103n spotr2=103n spobr2=103n nf=2
VI00n_rb (VI00n_cb VDD 0) resistor r=1M
VI10p_mv (OUTP VI10p_cb VI10p_cb) moscap_rf wr=538n lr=200n gr=2 br=2 multi=1 sobn=470n sobs=470n sobw=684n sobe=684n nfin=2
VI10p_sw (VCTRL_I ENI1 VI10p_cb VDD) pch_svt_mac l=16n nfin=2 w=58n multi=1 sd=74n sa=90n sb=90n ploda1=16n ploda2=0 ploda3=0 plodb1=16n plodb2=0 plodb3=0 nf_flag=1 smbt=1M smbb=1M dinsaflag=0 ppitch=0 spot=103n spob=103n spotl1=103n spobl1=103n spotl2=103n spobl2=103n spotr1=103n spobr1=103n spotr2=103n spobr2=103n nf=2
VI10p_rb (VI10p_cb VDD 0) resistor r=1M
VI10n_mv (OUTN VI10n_cb VI10n_cb) moscap_rf wr=538n lr=200n gr=2 br=2 multi=1 sobn=470n sobs=470n sobw=684n sobe=684n nfin=2
VI10n_sw (VCTRL_I ENI1 VI10n_cb VDD) pch_svt_mac l=16n nfin=2 w=58n multi=1 sd=74n sa=90n sb=90n ploda1=16n ploda2=0 ploda3=0 plodb1=16n plodb2=0 plodb3=0 nf_flag=1 smbt=1M smbb=1M dinsaflag=0 ppitch=0 spot=103n spob=103n spotl1=103n spobl1=103n spotl2=103n spobl2=103n spotr1=103n spobr1=103n spotr2=103n spobr2=103n nf=2
VI10n_rb (VI10n_cb VDD 0) resistor r=1M
VI20p_mv (OUTP VI20p_cb VI20p_cb) moscap_rf wr=538n lr=200n gr=2 br=2 multi=1 sobn=470n sobs=470n sobw=684n sobe=684n nfin=4
VI20p_sw (VCTRL_I ENI2 VI20p_cb VDD) pch_svt_mac l=16n nfin=2 w=58n multi=1 sd=74n sa=90n sb=90n ploda1=16n ploda2=0 ploda3=0 plodb1=16n plodb2=0 plodb3=0 nf_flag=1 smbt=1M smbb=1M dinsaflag=0 ppitch=0 spot=103n spob=103n spotl1=103n spobl1=103n spotl2=103n spobl2=103n spotr1=103n spobr1=103n spotr2=103n spobr2=103n nf=2
VI20p_rb (VI20p_cb VDD 0) resistor r=1M
VI20n_mv (OUTN VI20n_cb VI20n_cb) moscap_rf wr=538n lr=200n gr=2 br=2 multi=1 sobn=470n sobs=470n sobw=684n sobe=684n nfin=4
VI20n_sw (VCTRL_I ENI2 VI20n_cb VDD) pch_svt_mac l=16n nfin=2 w=58n multi=1 sd=74n sa=90n sb=90n ploda1=16n ploda2=0 ploda3=0 plodb1=16n plodb2=0 plodb3=0 nf_flag=1 smbt=1M smbb=1M dinsaflag=0 ppitch=0 spot=103n spob=103n spotl1=103n spobl1=103n spotl2=103n spobl2=103n spotr1=103n spobr1=103n spotr2=103n spobr2=103n nf=2
VI20n_rb (VI20n_cb VDD 0) resistor r=1M
VP00p_mv (OUTP VP00p_cb VP00p_cb) moscap_rf wr=538n lr=200n gr=2 br=2 multi=1 sobn=470n sobs=470n sobw=684n sobe=684n nfin=1
VP00p_sw (VCTRL_P ENP0 VP00p_cb VDD) pch_svt_mac l=16n nfin=2 w=58n multi=1 sd=74n sa=90n sb=90n ploda1=16n ploda2=0 ploda3=0 plodb1=16n plodb2=0 plodb3=0 nf_flag=1 smbt=1M smbb=1M dinsaflag=0 ppitch=0 spot=103n spob=103n spotl1=103n spobl1=103n spotl2=103n spobl2=103n spotr1=103n spobr1=103n spotr2=103n spobr2=103n nf=2
VP00p_rb (VP00p_cb VDD 0) resistor r=1M
VP00n_mv (OUTN VP00n_cb VP00n_cb) moscap_rf wr=538n lr=200n gr=2 br=2 multi=1 sobn=470n sobs=470n sobw=684n sobe=684n nfin=1
VP00n_sw (VCTRL_P ENP0 VP00n_cb VDD) pch_svt_mac l=16n nfin=2 w=58n multi=1 sd=74n sa=90n sb=90n ploda1=16n ploda2=0 ploda3=0 plodb1=16n plodb2=0 plodb3=0 nf_flag=1 smbt=1M smbb=1M dinsaflag=0 ppitch=0 spot=103n spob=103n spotl1=103n spobl1=103n spotl2=103n spobl2=103n spotr1=103n spobr1=103n spotr2=103n spobr2=103n nf=2
VP00n_rb (VP00n_cb VDD 0) resistor r=1M
VP10p_mv (OUTP VP10p_cb VP10p_cb) moscap_rf wr=538n lr=200n gr=2 br=2 multi=1 sobn=470n sobs=470n sobw=684n sobe=684n nfin=1
VP10p_sw (VCTRL_P ENP1 VP10p_cb VDD) pch_svt_mac l=16n nfin=2 w=58n multi=1 sd=74n sa=90n sb=90n ploda1=16n ploda2=0 ploda3=0 plodb1=16n plodb2=0 plodb3=0 nf_flag=1 smbt=1M smbb=1M dinsaflag=0 ppitch=0 spot=103n spob=103n spotl1=103n spobl1=103n spotl2=103n spobl2=103n spotr1=103n spobr1=103n spotr2=103n spobr2=103n nf=2
VP10p_rb (VP10p_cb VDD 0) resistor r=1M
VP10n_mv (OUTN VP10n_cb VP10n_cb) moscap_rf wr=538n lr=200n gr=2 br=2 multi=1 sobn=470n sobs=470n sobw=684n sobe=684n nfin=1
VP10n_sw (VCTRL_P ENP1 VP10n_cb VDD) pch_svt_mac l=16n nfin=2 w=58n multi=1 sd=74n sa=90n sb=90n ploda1=16n ploda2=0 ploda3=0 plodb1=16n plodb2=0 plodb3=0 nf_flag=1 smbt=1M smbb=1M dinsaflag=0 ppitch=0 spot=103n spob=103n spotl1=103n spobl1=103n spotl2=103n spobl2=103n spotr1=103n spobr1=103n spotr2=103n spobr2=103n nf=2
VP10n_rb (VP10n_cb VDD 0) resistor r=1M
VP11p_mv (OUTP VP11p_cb VP11p_cb) moscap_rf wr=538n lr=200n gr=2 br=2 multi=1 sobn=470n sobs=470n sobw=684n sobe=684n nfin=1
VP11p_sw (VCTRL_P ENP1 VP11p_cb VDD) pch_svt_mac l=16n nfin=2 w=58n multi=1 sd=74n sa=90n sb=90n ploda1=16n ploda2=0 ploda3=0 plodb1=16n plodb2=0 plodb3=0 nf_flag=1 smbt=1M smbb=1M dinsaflag=0 ppitch=0 spot=103n spob=103n spotl1=103n spobl1=103n spotl2=103n spobl2=103n spotr1=103n spobr1=103n spotr2=103n spobr2=103n nf=2
VP11p_rb (VP11p_cb VDD 0) resistor r=1M
VP11n_mv (OUTN VP11n_cb VP11n_cb) moscap_rf wr=538n lr=200n gr=2 br=2 multi=1 sobn=470n sobs=470n sobw=684n sobe=684n nfin=1
VP11n_sw (VCTRL_P ENP1 VP11n_cb VDD) pch_svt_mac l=16n nfin=2 w=58n multi=1 sd=74n sa=90n sb=90n ploda1=16n ploda2=0 ploda3=0 plodb1=16n plodb2=0 plodb3=0 nf_flag=1 smbt=1M smbb=1M dinsaflag=0 ppitch=0 spot=103n spob=103n spotl1=103n spobl1=103n spotl2=103n spobl2=103n spotr1=103n spobr1=103n spotr2=103n spobr2=103n nf=2
VP11n_rb (VP11n_cb VDD 0) resistor r=1M
VP20p_mv (OUTP VP20p_cb VP20p_cb) moscap_rf wr=538n lr=200n gr=2 br=2 multi=1 sobn=470n sobs=470n sobw=684n sobe=684n nfin=1
VP20p_sw (VCTRL_P ENP2 VP20p_cb VDD) pch_svt_mac l=16n nfin=2 w=58n multi=1 sd=74n sa=90n sb=90n ploda1=16n ploda2=0 ploda3=0 plodb1=16n plodb2=0 plodb3=0 nf_flag=1 smbt=1M smbb=1M dinsaflag=0 ppitch=0 spot=103n spob=103n spotl1=103n spobl1=103n spotl2=103n spobl2=103n spotr1=103n spobr1=103n spotr2=103n spobr2=103n nf=2
VP20p_rb (VP20p_cb VDD 0) resistor r=1M
VP20n_mv (OUTN VP20n_cb VP20n_cb) moscap_rf wr=538n lr=200n gr=2 br=2 multi=1 sobn=470n sobs=470n sobw=684n sobe=684n nfin=1
VP20n_sw (VCTRL_P ENP2 VP20n_cb VDD) pch_svt_mac l=16n nfin=2 w=58n multi=1 sd=74n sa=90n sb=90n ploda1=16n ploda2=0 ploda3=0 plodb1=16n plodb2=0 plodb3=0 nf_flag=1 smbt=1M smbb=1M dinsaflag=0 ppitch=0 spot=103n spob=103n spotl1=103n spobl1=103n spotl2=103n spobl2=103n spotr1=103n spobr1=103n spotr2=103n spobr2=103n nf=2
VP20n_rb (VP20n_cb VDD 0) resistor r=1M
VP21p_mv (OUTP VP21p_cb VP21p_cb) moscap_rf wr=538n lr=200n gr=2 br=2 multi=1 sobn=470n sobs=470n sobw=684n sobe=684n nfin=1
VP21p_sw (VCTRL_P ENP2 VP21p_cb VDD) pch_svt_mac l=16n nfin=2 w=58n multi=1 sd=74n sa=90n sb=90n ploda1=16n ploda2=0 ploda3=0 plodb1=16n plodb2=0 plodb3=0 nf_flag=1 smbt=1M smbb=1M dinsaflag=0 ppitch=0 spot=103n spob=103n spotl1=103n spobl1=103n spotl2=103n spobl2=103n spotr1=103n spobr1=103n spotr2=103n spobr2=103n nf=2
VP21p_rb (VP21p_cb VDD 0) resistor r=1M
VP21n_mv (OUTN VP21n_cb VP21n_cb) moscap_rf wr=538n lr=200n gr=2 br=2 multi=1 sobn=470n sobs=470n sobw=684n sobe=684n nfin=1
VP21n_sw (VCTRL_P ENP2 VP21n_cb VDD) pch_svt_mac l=16n nfin=2 w=58n multi=1 sd=74n sa=90n sb=90n ploda1=16n ploda2=0 ploda3=0 plodb1=16n plodb2=0 plodb3=0 nf_flag=1 smbt=1M smbb=1M dinsaflag=0 ppitch=0 spot=103n spob=103n spotl1=103n spobl1=103n spotl2=103n spobl2=103n spotr1=103n spobr1=103n spotr2=103n spobr2=103n nf=2
VP21n_rb (VP21n_cb VDD 0) resistor r=1M
VP22p_mv (OUTP VP22p_cb VP22p_cb) moscap_rf wr=538n lr=200n gr=2 br=2 multi=1 sobn=470n sobs=470n sobw=684n sobe=684n nfin=1
VP22p_sw (VCTRL_P ENP2 VP22p_cb VDD) pch_svt_mac l=16n nfin=2 w=58n multi=1 sd=74n sa=90n sb=90n ploda1=16n ploda2=0 ploda3=0 plodb1=16n plodb2=0 plodb3=0 nf_flag=1 smbt=1M smbb=1M dinsaflag=0 ppitch=0 spot=103n spob=103n spotl1=103n spobl1=103n spotl2=103n spobl2=103n spotr1=103n spobr1=103n spotr2=103n spobr2=103n nf=2
VP22p_rb (VP22p_cb VDD 0) resistor r=1M
VP22n_mv (OUTN VP22n_cb VP22n_cb) moscap_rf wr=538n lr=200n gr=2 br=2 multi=1 sobn=470n sobs=470n sobw=684n sobe=684n nfin=1
VP22n_sw (VCTRL_P ENP2 VP22n_cb VDD) pch_svt_mac l=16n nfin=2 w=58n multi=1 sd=74n sa=90n sb=90n ploda1=16n ploda2=0 ploda3=0 plodb1=16n plodb2=0 plodb3=0 nf_flag=1 smbt=1M smbb=1M dinsaflag=0 ppitch=0 spot=103n spob=103n spotl1=103n spobl1=103n spotl2=103n spobl2=103n spotr1=103n spobr1=103n spotr2=103n spobr2=103n nf=2
VP22n_rb (VP22n_cb VDD 0) resistor r=1M
VP23p_mv (OUTP VP23p_cb VP23p_cb) moscap_rf wr=538n lr=200n gr=2 br=2 multi=1 sobn=470n sobs=470n sobw=684n sobe=684n nfin=1
VP23p_sw (VCTRL_P ENP2 VP23p_cb VDD) pch_svt_mac l=16n nfin=2 w=58n multi=1 sd=74n sa=90n sb=90n ploda1=16n ploda2=0 ploda3=0 plodb1=16n plodb2=0 plodb3=0 nf_flag=1 smbt=1M smbb=1M dinsaflag=0 ppitch=0 spot=103n spob=103n spotl1=103n spobl1=103n spotl2=103n spobl2=103n spotr1=103n spobr1=103n spotr2=103n spobr2=103n nf=2
VP23p_rb (VP23p_cb VDD 0) resistor r=1M
VP23n_mv (OUTN VP23n_cb VP23n_cb) moscap_rf wr=538n lr=200n gr=2 br=2 multi=1 sobn=470n sobs=470n sobw=684n sobe=684n nfin=1
VP23n_sw (VCTRL_P ENP2 VP23n_cb VDD) pch_svt_mac l=16n nfin=2 w=58n multi=1 sd=74n sa=90n sb=90n ploda1=16n ploda2=0 ploda3=0 plodb1=16n plodb2=0 plodb3=0 nf_flag=1 smbt=1M smbb=1M dinsaflag=0 ppitch=0 spot=103n spob=103n spotl1=103n spobl1=103n spotl2=103n spobl2=103n spotr1=103n spobr1=103n spotr2=103n spobr2=103n nf=2
VP23n_rb (VP23n_cb VDD 0) resistor r=1M
VP30p_mv (OUTP VP30p_cb VP30p_cb) moscap_rf wr=538n lr=200n gr=2 br=2 multi=1 sobn=470n sobs=470n sobw=684n sobe=684n nfin=1
VP30p_sw (VCTRL_P ENP3 VP30p_cb VDD) pch_svt_mac l=16n nfin=2 w=58n multi=1 sd=74n sa=90n sb=90n ploda1=16n ploda2=0 ploda3=0 plodb1=16n plodb2=0 plodb3=0 nf_flag=1 smbt=1M smbb=1M dinsaflag=0 ppitch=0 spot=103n spob=103n spotl1=103n spobl1=103n spotl2=103n spobl2=103n spotr1=103n spobr1=103n spotr2=103n spobr2=103n nf=2
VP30p_rb (VP30p_cb VDD 0) resistor r=1M
VP30n_mv (OUTN VP30n_cb VP30n_cb) moscap_rf wr=538n lr=200n gr=2 br=2 multi=1 sobn=470n sobs=470n sobw=684n sobe=684n nfin=1
VP30n_sw (VCTRL_P ENP3 VP30n_cb VDD) pch_svt_mac l=16n nfin=2 w=58n multi=1 sd=74n sa=90n sb=90n ploda1=16n ploda2=0 ploda3=0 plodb1=16n plodb2=0 plodb3=0 nf_flag=1 smbt=1M smbb=1M dinsaflag=0 ppitch=0 spot=103n spob=103n spotl1=103n spobl1=103n spotl2=103n spobl2=103n spotr1=103n spobr1=103n spotr2=103n spobr2=103n nf=2
VP30n_rb (VP30n_cb VDD 0) resistor r=1M
VP31p_mv (OUTP VP31p_cb VP31p_cb) moscap_rf wr=538n lr=200n gr=2 br=2 multi=1 sobn=470n sobs=470n sobw=684n sobe=684n nfin=1
VP31p_sw (VCTRL_P ENP3 VP31p_cb VDD) pch_svt_mac l=16n nfin=2 w=58n multi=1 sd=74n sa=90n sb=90n ploda1=16n ploda2=0 ploda3=0 plodb1=16n plodb2=0 plodb3=0 nf_flag=1 smbt=1M smbb=1M dinsaflag=0 ppitch=0 spot=103n spob=103n spotl1=103n spobl1=103n spotl2=103n spobl2=103n spotr1=103n spobr1=103n spotr2=103n spobr2=103n nf=2
VP31p_rb (VP31p_cb VDD 0) resistor r=1M
VP31n_mv (OUTN VP31n_cb VP31n_cb) moscap_rf wr=538n lr=200n gr=2 br=2 multi=1 sobn=470n sobs=470n sobw=684n sobe=684n nfin=1
VP31n_sw (VCTRL_P ENP3 VP31n_cb VDD) pch_svt_mac l=16n nfin=2 w=58n multi=1 sd=74n sa=90n sb=90n ploda1=16n ploda2=0 ploda3=0 plodb1=16n plodb2=0 plodb3=0 nf_flag=1 smbt=1M smbb=1M dinsaflag=0 ppitch=0 spot=103n spob=103n spotl1=103n spobl1=103n spotl2=103n spobl2=103n spotr1=103n spobr1=103n spotr2=103n spobr2=103n nf=2
VP31n_rb (VP31n_cb VDD 0) resistor r=1M
VP32p_mv (OUTP VP32p_cb VP32p_cb) moscap_rf wr=538n lr=200n gr=2 br=2 multi=1 sobn=470n sobs=470n sobw=684n sobe=684n nfin=1
VP32p_sw (VCTRL_P ENP3 VP32p_cb VDD) pch_svt_mac l=16n nfin=2 w=58n multi=1 sd=74n sa=90n sb=90n ploda1=16n ploda2=0 ploda3=0 plodb1=16n plodb2=0 plodb3=0 nf_flag=1 smbt=1M smbb=1M dinsaflag=0 ppitch=0 spot=103n spob=103n spotl1=103n spobl1=103n spotl2=103n spobl2=103n spotr1=103n spobr1=103n spotr2=103n spobr2=103n nf=2
VP32p_rb (VP32p_cb VDD 0) resistor r=1M
VP32n_mv (OUTN VP32n_cb VP32n_cb) moscap_rf wr=538n lr=200n gr=2 br=2 multi=1 sobn=470n sobs=470n sobw=684n sobe=684n nfin=1
VP32n_sw (VCTRL_P ENP3 VP32n_cb VDD) pch_svt_mac l=16n nfin=2 w=58n multi=1 sd=74n sa=90n sb=90n ploda1=16n ploda2=0 ploda3=0 plodb1=16n plodb2=0 plodb3=0 nf_flag=1 smbt=1M smbb=1M dinsaflag=0 ppitch=0 spot=103n spob=103n spotl1=103n spobl1=103n spotl2=103n spobl2=103n spotr1=103n spobr1=103n spotr2=103n spobr2=103n nf=2
VP32n_rb (VP32n_cb VDD 0) resistor r=1M
VP33p_mv (OUTP VP33p_cb VP33p_cb) moscap_rf wr=538n lr=200n gr=2 br=2 multi=1 sobn=470n sobs=470n sobw=684n sobe=684n nfin=1
VP33p_sw (VCTRL_P ENP3 VP33p_cb VDD) pch_svt_mac l=16n nfin=2 w=58n multi=1 sd=74n sa=90n sb=90n ploda1=16n ploda2=0 ploda3=0 plodb1=16n plodb2=0 plodb3=0 nf_flag=1 smbt=1M smbb=1M dinsaflag=0 ppitch=0 spot=103n spob=103n spotl1=103n spobl1=103n spotl2=103n spobl2=103n spotr1=103n spobr1=103n spotr2=103n spobr2=103n nf=2
VP33p_rb (VP33p_cb VDD 0) resistor r=1M
VP33n_mv (OUTN VP33n_cb VP33n_cb) moscap_rf wr=538n lr=200n gr=2 br=2 multi=1 sobn=470n sobs=470n sobw=684n sobe=684n nfin=1
VP33n_sw (VCTRL_P ENP3 VP33n_cb VDD) pch_svt_mac l=16n nfin=2 w=58n multi=1 sd=74n sa=90n sb=90n ploda1=16n ploda2=0 ploda3=0 plodb1=16n plodb2=0 plodb3=0 nf_flag=1 smbt=1M smbb=1M dinsaflag=0 ppitch=0 spot=103n spob=103n spotl1=103n spobl1=103n spotl2=103n spobl2=103n spotr1=103n spobr1=103n spotr2=103n spobr2=103n nf=2
VP33n_rb (VP33n_cb VDD 0) resistor r=1M
VP34p_mv (OUTP VP34p_cb VP34p_cb) moscap_rf wr=538n lr=200n gr=2 br=2 multi=1 sobn=470n sobs=470n sobw=684n sobe=684n nfin=1
VP34p_sw (VCTRL_P ENP3 VP34p_cb VDD) pch_svt_mac l=16n nfin=2 w=58n multi=1 sd=74n sa=90n sb=90n ploda1=16n ploda2=0 ploda3=0 plodb1=16n plodb2=0 plodb3=0 nf_flag=1 smbt=1M smbb=1M dinsaflag=0 ppitch=0 spot=103n spob=103n spotl1=103n spobl1=103n spotl2=103n spobl2=103n spotr1=103n spobr1=103n spotr2=103n spobr2=103n nf=2
VP34p_rb (VP34p_cb VDD 0) resistor r=1M
VP34n_mv (OUTN VP34n_cb VP34n_cb) moscap_rf wr=538n lr=200n gr=2 br=2 multi=1 sobn=470n sobs=470n sobw=684n sobe=684n nfin=1
VP34n_sw (VCTRL_P ENP3 VP34n_cb VDD) pch_svt_mac l=16n nfin=2 w=58n multi=1 sd=74n sa=90n sb=90n ploda1=16n ploda2=0 ploda3=0 plodb1=16n plodb2=0 plodb3=0 nf_flag=1 smbt=1M smbb=1M dinsaflag=0 ppitch=0 spot=103n spob=103n spotl1=103n spobl1=103n spotl2=103n spobl2=103n spotr1=103n spobr1=103n spotr2=103n spobr2=103n nf=2
VP34n_rb (VP34n_cb VDD 0) resistor r=1M
VP35p_mv (OUTP VP35p_cb VP35p_cb) moscap_rf wr=538n lr=200n gr=2 br=2 multi=1 sobn=470n sobs=470n sobw=684n sobe=684n nfin=1
VP35p_sw (VCTRL_P ENP3 VP35p_cb VDD) pch_svt_mac l=16n nfin=2 w=58n multi=1 sd=74n sa=90n sb=90n ploda1=16n ploda2=0 ploda3=0 plodb1=16n plodb2=0 plodb3=0 nf_flag=1 smbt=1M smbb=1M dinsaflag=0 ppitch=0 spot=103n spob=103n spotl1=103n spobl1=103n spotl2=103n spobl2=103n spotr1=103n spobr1=103n spotr2=103n spobr2=103n nf=2
VP35p_rb (VP35p_cb VDD 0) resistor r=1M
VP35n_mv (OUTN VP35n_cb VP35n_cb) moscap_rf wr=538n lr=200n gr=2 br=2 multi=1 sobn=470n sobs=470n sobw=684n sobe=684n nfin=1
VP35n_sw (VCTRL_P ENP3 VP35n_cb VDD) pch_svt_mac l=16n nfin=2 w=58n multi=1 sd=74n sa=90n sb=90n ploda1=16n ploda2=0 ploda3=0 plodb1=16n plodb2=0 plodb3=0 nf_flag=1 smbt=1M smbb=1M dinsaflag=0 ppitch=0 spot=103n spob=103n spotl1=103n spobl1=103n spotl2=103n spobl2=103n spotr1=103n spobr1=103n spotr2=103n spobr2=103n nf=2
VP35n_rb (VP35n_cb VDD 0) resistor r=1M
VP36p_mv (OUTP VP36p_cb VP36p_cb) moscap_rf wr=538n lr=200n gr=2 br=2 multi=1 sobn=470n sobs=470n sobw=684n sobe=684n nfin=1
VP36p_sw (VCTRL_P ENP3 VP36p_cb VDD) pch_svt_mac l=16n nfin=2 w=58n multi=1 sd=74n sa=90n sb=90n ploda1=16n ploda2=0 ploda3=0 plodb1=16n plodb2=0 plodb3=0 nf_flag=1 smbt=1M smbb=1M dinsaflag=0 ppitch=0 spot=103n spob=103n spotl1=103n spobl1=103n spotl2=103n spobl2=103n spotr1=103n spobr1=103n spotr2=103n spobr2=103n nf=2
VP36p_rb (VP36p_cb VDD 0) resistor r=1M
VP36n_mv (OUTN VP36n_cb VP36n_cb) moscap_rf wr=538n lr=200n gr=2 br=2 multi=1 sobn=470n sobs=470n sobw=684n sobe=684n nfin=1
VP36n_sw (VCTRL_P ENP3 VP36n_cb VDD) pch_svt_mac l=16n nfin=2 w=58n multi=1 sd=74n sa=90n sb=90n ploda1=16n ploda2=0 ploda3=0 plodb1=16n plodb2=0 plodb3=0 nf_flag=1 smbt=1M smbb=1M dinsaflag=0 ppitch=0 spot=103n spob=103n spotl1=103n spobl1=103n spotl2=103n spobl2=103n spotr1=103n spobr1=103n spotr2=103n spobr2=103n nf=2
VP36n_rb (VP36n_cb VDD 0) resistor r=1M
VP37p_mv (OUTP VP37p_cb VP37p_cb) moscap_rf wr=538n lr=200n gr=2 br=2 multi=1 sobn=470n sobs=470n sobw=684n sobe=684n nfin=1
VP37p_sw (VCTRL_P ENP3 VP37p_cb VDD) pch_svt_mac l=16n nfin=2 w=58n multi=1 sd=74n sa=90n sb=90n ploda1=16n ploda2=0 ploda3=0 plodb1=16n plodb2=0 plodb3=0 nf_flag=1 smbt=1M smbb=1M dinsaflag=0 ppitch=0 spot=103n spob=103n spotl1=103n spobl1=103n spotl2=103n spobl2=103n spotr1=103n spobr1=103n spotr2=103n spobr2=103n nf=2
VP37p_rb (VP37p_cb VDD 0) resistor r=1M
VP37n_mv (OUTN VP37n_cb VP37n_cb) moscap_rf wr=538n lr=200n gr=2 br=2 multi=1 sobn=470n sobs=470n sobw=684n sobe=684n nfin=1
VP37n_sw (VCTRL_P ENP3 VP37n_cb VDD) pch_svt_mac l=16n nfin=2 w=58n multi=1 sd=74n sa=90n sb=90n ploda1=16n ploda2=0 ploda3=0 plodb1=16n plodb2=0 plodb3=0 nf_flag=1 smbt=1M smbb=1M dinsaflag=0 ppitch=0 spot=103n spob=103n spotl1=103n spobl1=103n spotl2=103n spobl2=103n spotr1=103n spobr1=103n spotr2=103n spobr2=103n nf=2
VP37n_rb (VP37n_cb VDD 0) resistor r=1M
VP40p_mv (OUTP VP40p_cb VP40p_cb) moscap_rf wr=538n lr=200n gr=2 br=2 multi=1 sobn=470n sobs=470n sobw=684n sobe=684n nfin=1
VP40p_sw (VCTRL_P ENP4 VP40p_cb VDD) pch_svt_mac l=16n nfin=2 w=58n multi=1 sd=74n sa=90n sb=90n ploda1=16n ploda2=0 ploda3=0 plodb1=16n plodb2=0 plodb3=0 nf_flag=1 smbt=1M smbb=1M dinsaflag=0 ppitch=0 spot=103n spob=103n spotl1=103n spobl1=103n spotl2=103n spobl2=103n spotr1=103n spobr1=103n spotr2=103n spobr2=103n nf=2
VP40p_rb (VP40p_cb VDD 0) resistor r=1M
VP40n_mv (OUTN VP40n_cb VP40n_cb) moscap_rf wr=538n lr=200n gr=2 br=2 multi=1 sobn=470n sobs=470n sobw=684n sobe=684n nfin=1
VP40n_sw (VCTRL_P ENP4 VP40n_cb VDD) pch_svt_mac l=16n nfin=2 w=58n multi=1 sd=74n sa=90n sb=90n ploda1=16n ploda2=0 ploda3=0 plodb1=16n plodb2=0 plodb3=0 nf_flag=1 smbt=1M smbb=1M dinsaflag=0 ppitch=0 spot=103n spob=103n spotl1=103n spobl1=103n spotl2=103n spobl2=103n spotr1=103n spobr1=103n spotr2=103n spobr2=103n nf=2
VP40n_rb (VP40n_cb VDD 0) resistor r=1M
VP41p_mv (OUTP VP41p_cb VP41p_cb) moscap_rf wr=538n lr=200n gr=2 br=2 multi=1 sobn=470n sobs=470n sobw=684n sobe=684n nfin=1
VP41p_sw (VCTRL_P ENP4 VP41p_cb VDD) pch_svt_mac l=16n nfin=2 w=58n multi=1 sd=74n sa=90n sb=90n ploda1=16n ploda2=0 ploda3=0 plodb1=16n plodb2=0 plodb3=0 nf_flag=1 smbt=1M smbb=1M dinsaflag=0 ppitch=0 spot=103n spob=103n spotl1=103n spobl1=103n spotl2=103n spobl2=103n spotr1=103n spobr1=103n spotr2=103n spobr2=103n nf=2
VP41p_rb (VP41p_cb VDD 0) resistor r=1M
VP41n_mv (OUTN VP41n_cb VP41n_cb) moscap_rf wr=538n lr=200n gr=2 br=2 multi=1 sobn=470n sobs=470n sobw=684n sobe=684n nfin=1
VP41n_sw (VCTRL_P ENP4 VP41n_cb VDD) pch_svt_mac l=16n nfin=2 w=58n multi=1 sd=74n sa=90n sb=90n ploda1=16n ploda2=0 ploda3=0 plodb1=16n plodb2=0 plodb3=0 nf_flag=1 smbt=1M smbb=1M dinsaflag=0 ppitch=0 spot=103n spob=103n spotl1=103n spobl1=103n spotl2=103n spobl2=103n spotr1=103n spobr1=103n spotr2=103n spobr2=103n nf=2
VP41n_rb (VP41n_cb VDD 0) resistor r=1M
VP42p_mv (OUTP VP42p_cb VP42p_cb) moscap_rf wr=538n lr=200n gr=2 br=2 multi=1 sobn=470n sobs=470n sobw=684n sobe=684n nfin=1
VP42p_sw (VCTRL_P ENP4 VP42p_cb VDD) pch_svt_mac l=16n nfin=2 w=58n multi=1 sd=74n sa=90n sb=90n ploda1=16n ploda2=0 ploda3=0 plodb1=16n plodb2=0 plodb3=0 nf_flag=1 smbt=1M smbb=1M dinsaflag=0 ppitch=0 spot=103n spob=103n spotl1=103n spobl1=103n spotl2=103n spobl2=103n spotr1=103n spobr1=103n spotr2=103n spobr2=103n nf=2
VP42p_rb (VP42p_cb VDD 0) resistor r=1M
VP42n_mv (OUTN VP42n_cb VP42n_cb) moscap_rf wr=538n lr=200n gr=2 br=2 multi=1 sobn=470n sobs=470n sobw=684n sobe=684n nfin=1
VP42n_sw (VCTRL_P ENP4 VP42n_cb VDD) pch_svt_mac l=16n nfin=2 w=58n multi=1 sd=74n sa=90n sb=90n ploda1=16n ploda2=0 ploda3=0 plodb1=16n plodb2=0 plodb3=0 nf_flag=1 smbt=1M smbb=1M dinsaflag=0 ppitch=0 spot=103n spob=103n spotl1=103n spobl1=103n spotl2=103n spobl2=103n spotr1=103n spobr1=103n spotr2=103n spobr2=103n nf=2
VP42n_rb (VP42n_cb VDD 0) resistor r=1M
VP43p_mv (OUTP VP43p_cb VP43p_cb) moscap_rf wr=538n lr=200n gr=2 br=2 multi=1 sobn=470n sobs=470n sobw=684n sobe=684n nfin=1
VP43p_sw (VCTRL_P ENP4 VP43p_cb VDD) pch_svt_mac l=16n nfin=2 w=58n multi=1 sd=74n sa=90n sb=90n ploda1=16n ploda2=0 ploda3=0 plodb1=16n plodb2=0 plodb3=0 nf_flag=1 smbt=1M smbb=1M dinsaflag=0 ppitch=0 spot=103n spob=103n spotl1=103n spobl1=103n spotl2=103n spobl2=103n spotr1=103n spobr1=103n spotr2=103n spobr2=103n nf=2
VP43p_rb (VP43p_cb VDD 0) resistor r=1M
VP43n_mv (OUTN VP43n_cb VP43n_cb) moscap_rf wr=538n lr=200n gr=2 br=2 multi=1 sobn=470n sobs=470n sobw=684n sobe=684n nfin=1
VP43n_sw (VCTRL_P ENP4 VP43n_cb VDD) pch_svt_mac l=16n nfin=2 w=58n multi=1 sd=74n sa=90n sb=90n ploda1=16n ploda2=0 ploda3=0 plodb1=16n plodb2=0 plodb3=0 nf_flag=1 smbt=1M smbb=1M dinsaflag=0 ppitch=0 spot=103n spob=103n spotl1=103n spobl1=103n spotl2=103n spobl2=103n spotr1=103n spobr1=103n spotr2=103n spobr2=103n nf=2
VP43n_rb (VP43n_cb VDD 0) resistor r=1M
VP44p_mv (OUTP VP44p_cb VP44p_cb) moscap_rf wr=538n lr=200n gr=2 br=2 multi=1 sobn=470n sobs=470n sobw=684n sobe=684n nfin=1
VP44p_sw (VCTRL_P ENP4 VP44p_cb VDD) pch_svt_mac l=16n nfin=2 w=58n multi=1 sd=74n sa=90n sb=90n ploda1=16n ploda2=0 ploda3=0 plodb1=16n plodb2=0 plodb3=0 nf_flag=1 smbt=1M smbb=1M dinsaflag=0 ppitch=0 spot=103n spob=103n spotl1=103n spobl1=103n spotl2=103n spobl2=103n spotr1=103n spobr1=103n spotr2=103n spobr2=103n nf=2
VP44p_rb (VP44p_cb VDD 0) resistor r=1M
VP44n_mv (OUTN VP44n_cb VP44n_cb) moscap_rf wr=538n lr=200n gr=2 br=2 multi=1 sobn=470n sobs=470n sobw=684n sobe=684n nfin=1
VP44n_sw (VCTRL_P ENP4 VP44n_cb VDD) pch_svt_mac l=16n nfin=2 w=58n multi=1 sd=74n sa=90n sb=90n ploda1=16n ploda2=0 ploda3=0 plodb1=16n plodb2=0 plodb3=0 nf_flag=1 smbt=1M smbb=1M dinsaflag=0 ppitch=0 spot=103n spob=103n spotl1=103n spobl1=103n spotl2=103n spobl2=103n spotr1=103n spobr1=103n spotr2=103n spobr2=103n nf=2
VP44n_rb (VP44n_cb VDD 0) resistor r=1M
VP45p_mv (OUTP VP45p_cb VP45p_cb) moscap_rf wr=538n lr=200n gr=2 br=2 multi=1 sobn=470n sobs=470n sobw=684n sobe=684n nfin=1
VP45p_sw (VCTRL_P ENP4 VP45p_cb VDD) pch_svt_mac l=16n nfin=2 w=58n multi=1 sd=74n sa=90n sb=90n ploda1=16n ploda2=0 ploda3=0 plodb1=16n plodb2=0 plodb3=0 nf_flag=1 smbt=1M smbb=1M dinsaflag=0 ppitch=0 spot=103n spob=103n spotl1=103n spobl1=103n spotl2=103n spobl2=103n spotr1=103n spobr1=103n spotr2=103n spobr2=103n nf=2
VP45p_rb (VP45p_cb VDD 0) resistor r=1M
VP45n_mv (OUTN VP45n_cb VP45n_cb) moscap_rf wr=538n lr=200n gr=2 br=2 multi=1 sobn=470n sobs=470n sobw=684n sobe=684n nfin=1
VP45n_sw (VCTRL_P ENP4 VP45n_cb VDD) pch_svt_mac l=16n nfin=2 w=58n multi=1 sd=74n sa=90n sb=90n ploda1=16n ploda2=0 ploda3=0 plodb1=16n plodb2=0 plodb3=0 nf_flag=1 smbt=1M smbb=1M dinsaflag=0 ppitch=0 spot=103n spob=103n spotl1=103n spobl1=103n spotl2=103n spobl2=103n spotr1=103n spobr1=103n spotr2=103n spobr2=103n nf=2
VP45n_rb (VP45n_cb VDD 0) resistor r=1M
VP46p_mv (OUTP VP46p_cb VP46p_cb) moscap_rf wr=538n lr=200n gr=2 br=2 multi=1 sobn=470n sobs=470n sobw=684n sobe=684n nfin=1
VP46p_sw (VCTRL_P ENP4 VP46p_cb VDD) pch_svt_mac l=16n nfin=2 w=58n multi=1 sd=74n sa=90n sb=90n ploda1=16n ploda2=0 ploda3=0 plodb1=16n plodb2=0 plodb3=0 nf_flag=1 smbt=1M smbb=1M dinsaflag=0 ppitch=0 spot=103n spob=103n spotl1=103n spobl1=103n spotl2=103n spobl2=103n spotr1=103n spobr1=103n spotr2=103n spobr2=103n nf=2
VP46p_rb (VP46p_cb VDD 0) resistor r=1M
VP46n_mv (OUTN VP46n_cb VP46n_cb) moscap_rf wr=538n lr=200n gr=2 br=2 multi=1 sobn=470n sobs=470n sobw=684n sobe=684n nfin=1
VP46n_sw (VCTRL_P ENP4 VP46n_cb VDD) pch_svt_mac l=16n nfin=2 w=58n multi=1 sd=74n sa=90n sb=90n ploda1=16n ploda2=0 ploda3=0 plodb1=16n plodb2=0 plodb3=0 nf_flag=1 smbt=1M smbb=1M dinsaflag=0 ppitch=0 spot=103n spob=103n spotl1=103n spobl1=103n spotl2=103n spobl2=103n spotr1=103n spobr1=103n spotr2=103n spobr2=103n nf=2
VP46n_rb (VP46n_cb VDD 0) resistor r=1M
VP47p_mv (OUTP VP47p_cb VP47p_cb) moscap_rf wr=538n lr=200n gr=2 br=2 multi=1 sobn=470n sobs=470n sobw=684n sobe=684n nfin=1
VP47p_sw (VCTRL_P ENP4 VP47p_cb VDD) pch_svt_mac l=16n nfin=2 w=58n multi=1 sd=74n sa=90n sb=90n ploda1=16n ploda2=0 ploda3=0 plodb1=16n plodb2=0 plodb3=0 nf_flag=1 smbt=1M smbb=1M dinsaflag=0 ppitch=0 spot=103n spob=103n spotl1=103n spobl1=103n spotl2=103n spobl2=103n spotr1=103n spobr1=103n spotr2=103n spobr2=103n nf=2
VP47p_rb (VP47p_cb VDD 0) resistor r=1M
VP47n_mv (OUTN VP47n_cb VP47n_cb) moscap_rf wr=538n lr=200n gr=2 br=2 multi=1 sobn=470n sobs=470n sobw=684n sobe=684n nfin=1
VP47n_sw (VCTRL_P ENP4 VP47n_cb VDD) pch_svt_mac l=16n nfin=2 w=58n multi=1 sd=74n sa=90n sb=90n ploda1=16n ploda2=0 ploda3=0 plodb1=16n plodb2=0 plodb3=0 nf_flag=1 smbt=1M smbb=1M dinsaflag=0 ppitch=0 spot=103n spob=103n spotl1=103n spobl1=103n spotl2=103n spobl2=103n spotr1=103n spobr1=103n spotr2=103n spobr2=103n nf=2
VP47n_rb (VP47n_cb VDD 0) resistor r=1M
VP48p_mv (OUTP VP48p_cb VP48p_cb) moscap_rf wr=538n lr=200n gr=2 br=2 multi=1 sobn=470n sobs=470n sobw=684n sobe=684n nfin=1
VP48p_sw (VCTRL_P ENP4 VP48p_cb VDD) pch_svt_mac l=16n nfin=2 w=58n multi=1 sd=74n sa=90n sb=90n ploda1=16n ploda2=0 ploda3=0 plodb1=16n plodb2=0 plodb3=0 nf_flag=1 smbt=1M smbb=1M dinsaflag=0 ppitch=0 spot=103n spob=103n spotl1=103n spobl1=103n spotl2=103n spobl2=103n spotr1=103n spobr1=103n spotr2=103n spobr2=103n nf=2
VP48p_rb (VP48p_cb VDD 0) resistor r=1M
VP48n_mv (OUTN VP48n_cb VP48n_cb) moscap_rf wr=538n lr=200n gr=2 br=2 multi=1 sobn=470n sobs=470n sobw=684n sobe=684n nfin=1
VP48n_sw (VCTRL_P ENP4 VP48n_cb VDD) pch_svt_mac l=16n nfin=2 w=58n multi=1 sd=74n sa=90n sb=90n ploda1=16n ploda2=0 ploda3=0 plodb1=16n plodb2=0 plodb3=0 nf_flag=1 smbt=1M smbb=1M dinsaflag=0 ppitch=0 spot=103n spob=103n spotl1=103n spobl1=103n spotl2=103n spobl2=103n spotr1=103n spobr1=103n spotr2=103n spobr2=103n nf=2
VP48n_rb (VP48n_cb VDD 0) resistor r=1M
VP49p_mv (OUTP VP49p_cb VP49p_cb) moscap_rf wr=538n lr=200n gr=2 br=2 multi=1 sobn=470n sobs=470n sobw=684n sobe=684n nfin=1
VP49p_sw (VCTRL_P ENP4 VP49p_cb VDD) pch_svt_mac l=16n nfin=2 w=58n multi=1 sd=74n sa=90n sb=90n ploda1=16n ploda2=0 ploda3=0 plodb1=16n plodb2=0 plodb3=0 nf_flag=1 smbt=1M smbb=1M dinsaflag=0 ppitch=0 spot=103n spob=103n spotl1=103n spobl1=103n spotl2=103n spobl2=103n spotr1=103n spobr1=103n spotr2=103n spobr2=103n nf=2
VP49p_rb (VP49p_cb VDD 0) resistor r=1M
VP49n_mv (OUTN VP49n_cb VP49n_cb) moscap_rf wr=538n lr=200n gr=2 br=2 multi=1 sobn=470n sobs=470n sobw=684n sobe=684n nfin=1
VP49n_sw (VCTRL_P ENP4 VP49n_cb VDD) pch_svt_mac l=16n nfin=2 w=58n multi=1 sd=74n sa=90n sb=90n ploda1=16n ploda2=0 ploda3=0 plodb1=16n plodb2=0 plodb3=0 nf_flag=1 smbt=1M smbb=1M dinsaflag=0 ppitch=0 spot=103n spob=103n spotl1=103n spobl1=103n spotl2=103n spobl2=103n spotr1=103n spobr1=103n spotr2=103n spobr2=103n nf=2
VP49n_rb (VP49n_cb VDD 0) resistor r=1M
VP410p_mv (OUTP VP410p_cb VP410p_cb) moscap_rf wr=538n lr=200n gr=2 br=2 multi=1 sobn=470n sobs=470n sobw=684n sobe=684n nfin=1
VP410p_sw (VCTRL_P ENP4 VP410p_cb VDD) pch_svt_mac l=16n nfin=2 w=58n multi=1 sd=74n sa=90n sb=90n ploda1=16n ploda2=0 ploda3=0 plodb1=16n plodb2=0 plodb3=0 nf_flag=1 smbt=1M smbb=1M dinsaflag=0 ppitch=0 spot=103n spob=103n spotl1=103n spobl1=103n spotl2=103n spobl2=103n spotr1=103n spobr1=103n spotr2=103n spobr2=103n nf=2
VP410p_rb (VP410p_cb VDD 0) resistor r=1M
VP410n_mv (OUTN VP410n_cb VP410n_cb) moscap_rf wr=538n lr=200n gr=2 br=2 multi=1 sobn=470n sobs=470n sobw=684n sobe=684n nfin=1
VP410n_sw (VCTRL_P ENP4 VP410n_cb VDD) pch_svt_mac l=16n nfin=2 w=58n multi=1 sd=74n sa=90n sb=90n ploda1=16n ploda2=0 ploda3=0 plodb1=16n plodb2=0 plodb3=0 nf_flag=1 smbt=1M smbb=1M dinsaflag=0 ppitch=0 spot=103n spob=103n spotl1=103n spobl1=103n spotl2=103n spobl2=103n spotr1=103n spobr1=103n spotr2=103n spobr2=103n nf=2
VP410n_rb (VP410n_cb VDD 0) resistor r=1M
VP411p_mv (OUTP VP411p_cb VP411p_cb) moscap_rf wr=538n lr=200n gr=2 br=2 multi=1 sobn=470n sobs=470n sobw=684n sobe=684n nfin=1
VP411p_sw (VCTRL_P ENP4 VP411p_cb VDD) pch_svt_mac l=16n nfin=2 w=58n multi=1 sd=74n sa=90n sb=90n ploda1=16n ploda2=0 ploda3=0 plodb1=16n plodb2=0 plodb3=0 nf_flag=1 smbt=1M smbb=1M dinsaflag=0 ppitch=0 spot=103n spob=103n spotl1=103n spobl1=103n spotl2=103n spobl2=103n spotr1=103n spobr1=103n spotr2=103n spobr2=103n nf=2
VP411p_rb (VP411p_cb VDD 0) resistor r=1M
VP411n_mv (OUTN VP411n_cb VP411n_cb) moscap_rf wr=538n lr=200n gr=2 br=2 multi=1 sobn=470n sobs=470n sobw=684n sobe=684n nfin=1
VP411n_sw (VCTRL_P ENP4 VP411n_cb VDD) pch_svt_mac l=16n nfin=2 w=58n multi=1 sd=74n sa=90n sb=90n ploda1=16n ploda2=0 ploda3=0 plodb1=16n plodb2=0 plodb3=0 nf_flag=1 smbt=1M smbb=1M dinsaflag=0 ppitch=0 spot=103n spob=103n spotl1=103n spobl1=103n spotl2=103n spobl2=103n spotr1=103n spobr1=103n spotr2=103n spobr2=103n nf=2
VP411n_rb (VP411n_cb VDD 0) resistor r=1M
VP412p_mv (OUTP VP412p_cb VP412p_cb) moscap_rf wr=538n lr=200n gr=2 br=2 multi=1 sobn=470n sobs=470n sobw=684n sobe=684n nfin=1
VP412p_sw (VCTRL_P ENP4 VP412p_cb VDD) pch_svt_mac l=16n nfin=2 w=58n multi=1 sd=74n sa=90n sb=90n ploda1=16n ploda2=0 ploda3=0 plodb1=16n plodb2=0 plodb3=0 nf_flag=1 smbt=1M smbb=1M dinsaflag=0 ppitch=0 spot=103n spob=103n spotl1=103n spobl1=103n spotl2=103n spobl2=103n spotr1=103n spobr1=103n spotr2=103n spobr2=103n nf=2
VP412p_rb (VP412p_cb VDD 0) resistor r=1M
VP412n_mv (OUTN VP412n_cb VP412n_cb) moscap_rf wr=538n lr=200n gr=2 br=2 multi=1 sobn=470n sobs=470n sobw=684n sobe=684n nfin=1
VP412n_sw (VCTRL_P ENP4 VP412n_cb VDD) pch_svt_mac l=16n nfin=2 w=58n multi=1 sd=74n sa=90n sb=90n ploda1=16n ploda2=0 ploda3=0 plodb1=16n plodb2=0 plodb3=0 nf_flag=1 smbt=1M smbb=1M dinsaflag=0 ppitch=0 spot=103n spob=103n spotl1=103n spobl1=103n spotl2=103n spobl2=103n spotr1=103n spobr1=103n spotr2=103n spobr2=103n nf=2
VP412n_rb (VP412n_cb VDD 0) resistor r=1M
VP413p_mv (OUTP VP413p_cb VP413p_cb) moscap_rf wr=538n lr=200n gr=2 br=2 multi=1 sobn=470n sobs=470n sobw=684n sobe=684n nfin=1
VP413p_sw (VCTRL_P ENP4 VP413p_cb VDD) pch_svt_mac l=16n nfin=2 w=58n multi=1 sd=74n sa=90n sb=90n ploda1=16n ploda2=0 ploda3=0 plodb1=16n plodb2=0 plodb3=0 nf_flag=1 smbt=1M smbb=1M dinsaflag=0 ppitch=0 spot=103n spob=103n spotl1=103n spobl1=103n spotl2=103n spobl2=103n spotr1=103n spobr1=103n spotr2=103n spobr2=103n nf=2
VP413p_rb (VP413p_cb VDD 0) resistor r=1M
VP413n_mv (OUTN VP413n_cb VP413n_cb) moscap_rf wr=538n lr=200n gr=2 br=2 multi=1 sobn=470n sobs=470n sobw=684n sobe=684n nfin=1
VP413n_sw (VCTRL_P ENP4 VP413n_cb VDD) pch_svt_mac l=16n nfin=2 w=58n multi=1 sd=74n sa=90n sb=90n ploda1=16n ploda2=0 ploda3=0 plodb1=16n plodb2=0 plodb3=0 nf_flag=1 smbt=1M smbb=1M dinsaflag=0 ppitch=0 spot=103n spob=103n spotl1=103n spobl1=103n spotl2=103n spobl2=103n spotr1=103n spobr1=103n spotr2=103n spobr2=103n nf=2
VP413n_rb (VP413n_cb VDD 0) resistor r=1M
VP414p_mv (OUTP VP414p_cb VP414p_cb) moscap_rf wr=538n lr=200n gr=2 br=2 multi=1 sobn=470n sobs=470n sobw=684n sobe=684n nfin=1
VP414p_sw (VCTRL_P ENP4 VP414p_cb VDD) pch_svt_mac l=16n nfin=2 w=58n multi=1 sd=74n sa=90n sb=90n ploda1=16n ploda2=0 ploda3=0 plodb1=16n plodb2=0 plodb3=0 nf_flag=1 smbt=1M smbb=1M dinsaflag=0 ppitch=0 spot=103n spob=103n spotl1=103n spobl1=103n spotl2=103n spobl2=103n spotr1=103n spobr1=103n spotr2=103n spobr2=103n nf=2
VP414p_rb (VP414p_cb VDD 0) resistor r=1M
VP414n_mv (OUTN VP414n_cb VP414n_cb) moscap_rf wr=538n lr=200n gr=2 br=2 multi=1 sobn=470n sobs=470n sobw=684n sobe=684n nfin=1
VP414n_sw (VCTRL_P ENP4 VP414n_cb VDD) pch_svt_mac l=16n nfin=2 w=58n multi=1 sd=74n sa=90n sb=90n ploda1=16n ploda2=0 ploda3=0 plodb1=16n plodb2=0 plodb3=0 nf_flag=1 smbt=1M smbb=1M dinsaflag=0 ppitch=0 spot=103n spob=103n spotl1=103n spobl1=103n spotl2=103n spobl2=103n spotr1=103n spobr1=103n spotr2=103n spobr2=103n nf=2
VP414n_rb (VP414n_cb VDD 0) resistor r=1M
VP415p_mv (OUTP VP415p_cb VP415p_cb) moscap_rf wr=538n lr=200n gr=2 br=2 multi=1 sobn=470n sobs=470n sobw=684n sobe=684n nfin=1
VP415p_sw (VCTRL_P ENP4 VP415p_cb VDD) pch_svt_mac l=16n nfin=2 w=58n multi=1 sd=74n sa=90n sb=90n ploda1=16n ploda2=0 ploda3=0 plodb1=16n plodb2=0 plodb3=0 nf_flag=1 smbt=1M smbb=1M dinsaflag=0 ppitch=0 spot=103n spob=103n spotl1=103n spobl1=103n spotl2=103n spobl2=103n spotr1=103n spobr1=103n spotr2=103n spobr2=103n nf=2
VP415p_rb (VP415p_cb VDD 0) resistor r=1M
VP415n_mv (OUTN VP415n_cb VP415n_cb) moscap_rf wr=538n lr=200n gr=2 br=2 multi=1 sobn=470n sobs=470n sobw=684n sobe=684n nfin=1
VP415n_sw (VCTRL_P ENP4 VP415n_cb VDD) pch_svt_mac l=16n nfin=2 w=58n multi=1 sd=74n sa=90n sb=90n ploda1=16n ploda2=0 ploda3=0 plodb1=16n plodb2=0 plodb3=0 nf_flag=1 smbt=1M smbb=1M dinsaflag=0 ppitch=0 spot=103n spob=103n spotl1=103n spobl1=103n spotl2=103n spobl2=103n spotr1=103n spobr1=103n spotr2=103n spobr2=103n nf=2
VP415n_rb (VP415n_cb VDD 0) resistor r=1M
ends vco_x_c

// vco_dual_8g_c — Plan C dual core: 0.5V cores + 0.8V enable logic
subckt vco_dual_8g_c (VDD VDDC VSS VCTRL_P VCTRL_I OUTP OUTN EN2 \
    ENI0 ENI1 ENI2 ENP0 ENP1 ENP2 ENP3 ENP4)
MNEN (EN2B EN2 VSS VSS) nch_ulvt_mac l=16n nfin=2 w=58n multi=1 sd=74n sa=90n sb=90n ploda1=16n ploda2=0 ploda3=0 plodb1=16n plodb2=0 plodb3=0 nf_flag=1 smbt=1M smbb=1M dinsaflag=0 ppitch=0 spot=103n spob=103n spotl1=103n spobl1=103n spotl2=103n spobl2=103n spotr1=103n spobr1=103n spotr2=103n spobr2=103n nf=2
MPEN (EN2B EN2 VDD VDD) pch_svt_mac l=16n nfin=2 w=58n multi=1 sd=74n sa=90n sb=90n ploda1=16n ploda2=0 ploda3=0 plodb1=16n plodb2=0 plodb3=0 nf_flag=1 smbt=1M smbb=1M dinsaflag=0 ppitch=0 spot=103n spob=103n spotl1=103n spobl1=103n spotl2=103n spobl2=103n spotr1=103n spobr1=103n spotr2=103n spobr2=103n nf=2
MPWRB (VDDB EN2B VDDC VDDC) pch_svt_mac l=16n nfin=2 w=58n multi=1 sd=74n sa=90n sb=90n ploda1=16n ploda2=0 ploda3=0 plodb1=16n plodb2=0 plodb3=0 nf_flag=1 smbt=1M smbb=1M dinsaflag=0 ppitch=0 spot=103n spob=103n spotl1=103n spobl1=103n spotl2=103n spobl2=103n spotr1=103n spobr1=103n spotr2=103n spobr2=103n nf=64
MSWP (OUTP EN2 OUTPB VSS) nch_ulvt_mac l=16n nfin=2 w=58n multi=1 sd=74n sa=90n sb=90n ploda1=16n ploda2=0 ploda3=0 plodb1=16n plodb2=0 plodb3=0 nf_flag=1 smbt=1M smbb=1M dinsaflag=0 ppitch=0 spot=103n spob=103n spotl1=103n spobl1=103n spotl2=103n spobl2=103n spotr1=103n spobr1=103n spotr2=103n spobr2=103n nf=64
MSWN (OUTN EN2 OUTNB VSS) nch_ulvt_mac l=16n nfin=2 w=58n multi=1 sd=74n sa=90n sb=90n ploda1=16n ploda2=0 ploda3=0 plodb1=16n plodb2=0 plodb3=0 nf_flag=1 smbt=1M smbb=1M dinsaflag=0 ppitch=0 spot=103n spob=103n spotl1=103n spobl1=103n spotl2=103n spobl2=103n spotr1=103n spobr1=103n spotr2=103n spobr2=103n nf=64
Xa (VDDC VSS VCTRL_P VCTRL_I OUTP OUTN ENI0 ENI1 ENI2 \
    ENP0 ENP1 ENP2 ENP3 ENP4) vco_x_c
Xb (VDDB VSS VCTRL_P VCTRL_I OUTPB OUTNB ENI0 ENI1 ENI2 \
    ENP0 ENP1 ENP2 ENP3 ENP4) vco_x_c
ends vco_dual_8g_c
