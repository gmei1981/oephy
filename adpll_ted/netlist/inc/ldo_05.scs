// ldo_05.scs — 0.5V VCO-core LDO (Plan C, paper Sec.IV Fig.12 LDO)
//
// Paper: STG1 folded-cascode error amp (100uA, UGB 100MHz) + STG2 master-slave
//        with RC LPF (fc~1MHz) on the master branch, unity feedback, VBGR
//        pre-filtered, PSR >55dB up to 10MHz. Supplies VDDOSC=0.5V from 1V.
//
// v1 simplifications (documented; iterate after PSR measurement):
//  - error amp = 5T OTA on 0.8V rail (paper: folded-cascode on 1V)
//  - single pass device + RC LPF between EA output and pass gate
//    (master-slave branch not yet implemented)
//  - reference VBG supplied externally (bandgap later)
//
// pins: VDD (0.8 analog rail, EA supply)  VIN (1.0)  VBG (0.5 ref)
//       VBL (EA tail bias, 0.7)           VOUT (0.5 regulated)  VSS
subckt ldo_05 (VDD VIN VBG VBL VOUT VSS)

// --- error amplifier ---
// VOUT -> MN1 (mirror side, non-inverting): VOUT up -> mirror current up ->
//   VDP up -> VGATE up -> pass OFF (negative feedback)
// VBG  -> MN2 (output side, inverting reference)
MN1 (VDN VOUT TAIL VSS) nch_ulvt_mac l=16n nfin=2 w=58n multi=1 nf=4 \
        sd=74n sa=90n sb=90n ploda1=16n ploda2=0 ploda3=0 plodb1=16n \
        plodb2=0 plodb3=0 nf_flag=1 smbt=1M smbb=1M dinsaflag=0 ppitch=0 \
        spot=103n spob=103n spotl1=103n spobl1=103n spotl2=103n \
        spobl2=103n spotr1=103n spobr1=103n spotr2=103n spobr2=103n
MN2 (VDP VBG TAIL VSS) nch_ulvt_mac l=16n nfin=2 w=58n multi=1 nf=4 \
        sd=74n sa=90n sb=90n ploda1=16n ploda2=0 ploda3=0 plodb1=16n \
        plodb2=0 plodb3=0 nf_flag=1 smbt=1M smbb=1M dinsaflag=0 ppitch=0 \
        spot=103n spob=103n spotl1=103n spobl1=103n spotl2=103n \
        spobl2=103n spotr1=103n spobr1=103n spotr2=103n spobr2=103n
MTAIL (TAIL VBL VSS VSS) nch_ulvt_mac l=16n nfin=2 w=58n multi=1 nf=1 \
        sd=74n sa=90n sb=90n ploda1=16n ploda2=0 ploda3=0 plodb1=16n \
        plodb2=0 plodb3=0 nf_flag=1 smbt=1M smbb=1M dinsaflag=0 ppitch=0 \
        spot=103n spob=103n spotl1=103n spobl1=103n spotl2=103n \
        spobl2=103n spotr1=103n spobr1=103n spotr2=103n spobr2=103n
MP1 (VDN VDN VDD VDD) pch_svt_mac l=16n nfin=2 w=58n multi=1 nf=2 \
        sd=74n sa=90n sb=90n ploda1=16n ploda2=0 ploda3=0 plodb1=16n \
        plodb2=0 plodb3=0 nf_flag=1 smbt=1M smbb=1M dinsaflag=0 ppitch=0 \
        spot=103n spob=103n spotl1=103n spobl1=103n spotl2=103n \
        spobl2=103n spotr1=103n spobr1=103n spotr2=103n spobr2=103n
MP2 (VDP VDN VDD VDD) pch_svt_mac l=16n nfin=2 w=58n multi=1 nf=2 \
        sd=74n sa=90n sb=90n ploda1=16n ploda2=0 ploda3=0 plodb1=16n \
        plodb2=0 plodb3=0 nf_flag=1 smbt=1M smbb=1M dinsaflag=0 ppitch=0 \
        spot=103n spob=103n spotl1=103n spobl1=103n spotl2=103n \
        spobl2=103n spotr1=103n spobr1=103n spotr2=103n spobr2=103n

// --- RC filter EA-out -> pass gate (paper STG2 flavor, fc ~ 1MHz) ---
RLPF (VDP VGATE) resistor r=2k
CLPF (VGATE VSS) capacitor c=2p

// --- pass device (PMOS, VIN=1.0 -> VOUT=0.5) ---
MPASS (VOUT VGATE VIN VIN) pch_svt_mac l=16n nfin=2 w=58n multi=1 nf=256 \
        sd=74n sa=90n sb=90n ploda1=16n ploda2=0 ploda3=0 plodb1=16n \
        plodb2=0 plodb3=0 nf_flag=1 smbt=1M smbb=1M dinsaflag=0 ppitch=0 \
        spot=103n spob=103n spotl1=103n spobl1=103n spotl2=103n \
        spobl2=103n spotr1=103n spobr1=103n spotr2=103n spobr2=103n
COUT (VOUT VSS) capacitor c=20p

ends ldo_05
