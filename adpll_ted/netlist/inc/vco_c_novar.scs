// vco_c.scs — generated by tools/gen_vco_c.py (Plan C, paper Sec.IV)
// core supply VDDC=0.5V from LDO (ldo_05.scs); logic/enables on VDD=0.8V
// EN=0 -> bank group enabled (PMOS bulk switch on); EN=0.8 -> disabled
// varactor = direct moscap_rf (series-cap cell REJECTED: model pump)

// vco_x_c — Plan C core: 0.5V supply, Ls tail inductor, VAR banks
subckt vco_x_c (VDD VSS VCTRL_P VCTRL_I OUTP OUTN ENI0 ENI1 ENI2 \
    ENP0 ENP1 ENP2 ENP3 ENP4)
MN1 (OUTP OUTN TAIL VSS) nch_ulvt_mac l=16n nfin=2 w=58n multi=1 sd=74n sa=90n sb=90n ploda1=16n ploda2=0 ploda3=0 plodb1=16n plodb2=0 plodb3=0 nf_flag=1 smbt=1M smbb=1M dinsaflag=0 ppitch=0 spot=103n spob=103n spotl1=103n spobl1=103n spotl2=103n spobl2=103n spotr1=103n spobr1=103n spotr2=103n spobr2=103n nf=16
MN0 (OUTN OUTP TAIL VSS) nch_ulvt_mac l=16n nfin=2 w=58n multi=1 sd=74n sa=90n sb=90n ploda1=16n ploda2=0 ploda3=0 plodb1=16n plodb2=0 plodb3=0 nf_flag=1 smbt=1M smbb=1M dinsaflag=0 ppitch=0 spot=103n spob=103n spotl1=103n spobl1=103n spotl2=103n spobl2=103n spotr1=103n spobr1=103n spotr2=103n spobr2=103n nf=16
Ls (TAIL VSS) inductor l=2n r=1
L1 (VDD OUTN) inductor l=1.5n r=2
L0 (VDD OUTP) inductor l=1.5n r=2
Cbyp (VDD VSS) capacitor c=10p
CF0 (OUTP OUTN VSS) cfmom_wo_p80 dmflag=0 lr=1u multi=1 mxd_flag=0 nr=165 n_mxa=2 shield=2 spm=3 stm=1 vapmod=2 grflag=1 gdis_t=185n gdis_b=185n gdis_l=102n gdis_r=102n
CF1 (OUTN net01 VSS) cfmom_wo_p80 dmflag=0 lr=1u multi=1 mxd_flag=0 nr=165 n_mxa=2 shield=2 spm=3 stm=1 vapmod=2 grflag=1 gdis_t=185n gdis_b=185n gdis_l=102n gdis_r=102n
CF2 (OUTN net02 VSS) cfmom_wo_p80 dmflag=0 lr=1u multi=1 mxd_flag=0 nr=165 n_mxa=2 shield=2 spm=3 stm=1 vapmod=2 grflag=1 gdis_t=185n gdis_b=185n gdis_l=102n gdis_r=102n
CF3 (OUTN net03 VSS) cfmom_wo_p80 dmflag=0 lr=1u multi=1 mxd_flag=0 nr=165 n_mxa=2 shield=2 spm=3 stm=1 vapmod=2 grflag=1 gdis_t=185n gdis_b=185n gdis_l=102n gdis_r=102n
CF4 (OUTN net04 VSS) cfmom_wo_p80 dmflag=0 lr=1u multi=1 mxd_flag=0 nr=165 n_mxa=2 shield=2 spm=3 stm=1 vapmod=2 grflag=1 gdis_t=185n gdis_b=185n gdis_l=102n gdis_r=102n
CF5 (OUTN net05 VSS) cfmom_wo_p80 dmflag=0 lr=1u multi=1 mxd_flag=0 nr=165 n_mxa=2 shield=2 spm=3 stm=1 vapmod=2 grflag=1 gdis_t=185n gdis_b=185n gdis_l=102n gdis_r=102n
CF6 (OUTP OUTN VSS) cfmom_wo_p80 dmflag=0 lr=1u multi=1 mxd_flag=0 nr=165 n_mxa=2 shield=2 spm=3 stm=1 vapmod=2 grflag=1 gdis_t=185n gdis_b=185n gdis_l=102n gdis_r=102n
CF7 (OUTN net07 VSS) cfmom_wo_p80 dmflag=0 lr=1u multi=1 mxd_flag=0 nr=165 n_mxa=2 shield=2 spm=3 stm=1 vapmod=2 grflag=1 gdis_t=185n gdis_b=185n gdis_l=102n gdis_r=102n
CF8 (OUTN net08 VSS) cfmom_wo_p80 dmflag=0 lr=1u multi=1 mxd_flag=0 nr=165 n_mxa=2 shield=2 spm=3 stm=1 vapmod=2 grflag=1 gdis_t=185n gdis_b=185n gdis_l=102n gdis_r=102n
CF9 (OUTN net09 VSS) cfmom_wo_p80 dmflag=0 lr=1u multi=1 mxd_flag=0 nr=165 n_mxa=2 shield=2 spm=3 stm=1 vapmod=2 grflag=1 gdis_t=185n gdis_b=185n gdis_l=102n gdis_r=102n
CF10 (OUTN net10 VSS) cfmom_wo_p80 dmflag=0 lr=1u multi=1 mxd_flag=0 nr=165 n_mxa=2 shield=2 spm=3 stm=1 vapmod=2 grflag=1 gdis_t=185n gdis_b=185n gdis_l=102n gdis_r=102n
CF11 (OUTN net11 VSS) cfmom_wo_p80 dmflag=0 lr=1u multi=1 mxd_flag=0 nr=165 n_mxa=2 shield=2 spm=3 stm=1 vapmod=2 grflag=1 gdis_t=185n gdis_b=185n gdis_l=102n gdis_r=102n
ends vco_x_c

// vco_dual_8g_c — Plan C dual core: 0.5V cores + 0.8V enable logic
subckt vco_dual_8g_c (VDD VDDC VSS VCTRL_P VCTRL_I OUTP OUTN EN2 \
    ENI0 ENI1 ENI2 ENP0 ENP1 ENP2 ENP3 ENP4)
MNEN (EN2B EN2 VSS VSS) nch_ulvt_mac l=16n nfin=2 w=58n multi=1 sd=74n sa=90n sb=90n ploda1=16n ploda2=0 ploda3=0 plodb1=16n plodb2=0 plodb3=0 nf_flag=1 smbt=1M smbb=1M dinsaflag=0 ppitch=0 spot=103n spob=103n spotl1=103n spobl1=103n spotl2=103n spobl2=103n spotr1=103n spobr1=103n spotr2=103n spobr2=103n nf=2
MPEN (EN2B EN2 VDD VDD) pch_svt_mac l=16n nfin=2 w=58n multi=1 sd=74n sa=90n sb=90n ploda1=16n ploda2=0 ploda3=0 plodb1=16n plodb2=0 plodb3=0 nf_flag=1 smbt=1M smbb=1M dinsaflag=0 ppitch=0 spot=103n spob=103n spotl1=103n spobl1=103n spotl2=103n spobl2=103n spotr1=103n spobr1=103n spotr2=103n spobr2=103n nf=2
MPWRB (VDDB EN2B VDDC VDDC) pch_svt_mac l=16n nfin=2 w=58n multi=1 sd=74n sa=90n sb=90n ploda1=16n ploda2=0 ploda3=0 plodb1=16n plodb2=0 plodb3=0 nf_flag=1 smbt=1M smbb=1M dinsaflag=0 ppitch=0 spot=103n spob=103n spotl1=103n spobl1=103n spotl2=103n spobl2=103n spotr1=103n spobr1=103n spotr2=103n spobr2=103n nf=64
MSWP (OUTP EN2 OUTPB VSS) nch_ulvt_mac l=16n nfin=2 w=58n multi=1 sd=74n sa=90n sb=90n ploda1=16n ploda2=0 ploda3=0 plodb1=16n plodb2=0 plodb3=0 nf_flag=1 smbt=1M smbb=1M dinsaflag=0 ppitch=0 spot=103n spob=103n spotl1=103n spobl1=103n spotl2=103n spobl2=103n spotr1=103n spobr1=103n spotr2=103n spobr2=103n nf=64
MSWN (OUTN EN2 OUTNB VSS) nch_ulvt_mac l=16n nfin=2 w=58n multi=1 sd=74n sa=90n sb=90n ploda1=16n ploda2=0 ploda3=0 plodb1=16n plodb2=0 plodb3=0 nf_flag=1 smbt=1M smbb=1M dinsaflag=0 ppitch=0 spot=103n spob=103n spotl1=103n spobl1=103n spotl2=103n spobl2=103n spotr1=103n spobr1=103n spotr2=103n spobr2=103n nf=64
Xa (VDDC VSS VCTRL_P VCTRL_I OUTP OUTN ENI0 ENI1 ENI2 \
    ENP0 ENP1 ENP2 ENP3 ENP4) vco_x_c
Xb (VDDB VSS VCTRL_P VCTRL_I OUTPB OUTNB ENI0 ENI1 ENI2 \
    ENP0 ENP1 ENP2 ENP3 ENP4) vco_x_c
ends vco_dual_8g_c
