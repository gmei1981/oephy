// afe_sch/afe_prbs23_gen/schematic
subckt afe_prbs23_gen vdd vout
ends afe_prbs23_gen

// afe_sch/afe_clk_gen/schematic
subckt afe_clk_gen ck8 pclk pi_code vdd
ends afe_clk_gen

// afe_sch/afe_pingpong/schematic
subckt afe_pingpong a_az a_eval b_az b_eval pclk vdd
ends afe_pingpong

// afe_sch/afe_samp/schematic
subckt afe_samp act_n act_p ck8 d_even d_odd vdd
ends afe_samp

// afe_sch/afe_ber_chk/schematic
subckt afe_ber_chk bit_cnt ck8 d_even d_odd err_cnt lock vdd
ends afe_ber_chk

// afe_sch/afe_tx_drv/schematic
subckt afe_tx_drv din pad vccio vdd vss
    Mp3d (n3 n2 vdd vdd) pch_svt_mac l=16.0n nfin=16 w=730.0n multi=1 nf=1 sd=74.0n sa=0 sb=0 ploda1=16.0n ploda2=0 ploda3=0 plodb1=16.0n plodb2=0 plodb3=0 nf_flag=1 smbt=1M smbb=1M dinsaflag=0 ppitch=0 spot=61.0n spob=61.0n spotl1=61.0n spobl1=61.0n spotl2=61.0n spobl2=61.0n spotr1=61.0n spobr1=61.0n spotr2=61.0n spobr2=61.0n
    Mp3c (n3 n2 vdd vdd) pch_svt_mac l=16.0n nfin=16 w=730.0n multi=1 nf=1 sd=74.0n sa=0 sb=0 ploda1=16.0n ploda2=0 ploda3=0 plodb1=16.0n plodb2=0 plodb3=0 nf_flag=1 smbt=1M smbb=1M dinsaflag=0 ppitch=0 spot=61.0n spob=61.0n spotl1=61.0n spobl1=61.0n spotl2=61.0n spobl2=61.0n spotr1=61.0n spobr1=61.0n spotr2=61.0n spobr2=61.0n
    Mp3b (n3 n2 vdd vdd) pch_svt_mac l=16.0n nfin=16 w=730.0n multi=1 nf=1 sd=74.0n sa=0 sb=0 ploda1=16.0n ploda2=0 ploda3=0 plodb1=16.0n plodb2=0 plodb3=0 nf_flag=1 smbt=1M smbb=1M dinsaflag=0 ppitch=0 spot=61.0n spob=61.0n spotl1=61.0n spobl1=61.0n spotl2=61.0n spobl2=61.0n spotr1=61.0n spobr1=61.0n spotr2=61.0n spobr2=61.0n
    Mp3a (n3 n2 vdd vdd) pch_svt_mac l=16.0n nfin=16 w=730.0n multi=1 nf=1 sd=74.0n sa=0 sb=0 ploda1=16.0n ploda2=0 ploda3=0 plodb1=16.0n plodb2=0 plodb3=0 nf_flag=1 smbt=1M smbb=1M dinsaflag=0 ppitch=0 spot=61.0n spob=61.0n spotl1=61.0n spobl1=61.0n spotl2=61.0n spobl2=61.0n spotr1=61.0n spobr1=61.0n spotr2=61.0n spobr2=61.0n
    Mp2c (n2 n1 vdd vdd) pch_svt_mac l=16.0n nfin=16 w=730.0n multi=1 nf=1 sd=74.0n sa=0 sb=0 ploda1=16.0n ploda2=0 ploda3=0 plodb1=16.0n plodb2=0 plodb3=0 nf_flag=1 smbt=1M smbb=1M dinsaflag=0 ppitch=0 spot=61.0n spob=61.0n spotl1=61.0n spobl1=61.0n spotl2=61.0n spobl2=61.0n spotr1=61.0n spobr1=61.0n spotr2=61.0n spobr2=61.0n
    Mp2b (n2 n1 vdd vdd) pch_svt_mac l=16.0n nfin=16 w=730.0n multi=1 nf=1 sd=74.0n sa=0 sb=0 ploda1=16.0n ploda2=0 ploda3=0 plodb1=16.0n plodb2=0 plodb3=0 nf_flag=1 smbt=1M smbb=1M dinsaflag=0 ppitch=0 spot=61.0n spob=61.0n spotl1=61.0n spobl1=61.0n spotl2=61.0n spobl2=61.0n spotr1=61.0n spobr1=61.0n spotr2=61.0n spobr2=61.0n
    Mp2a (n2 n1 vdd vdd) pch_svt_mac l=16.0n nfin=16 w=730.0n multi=1 nf=1 sd=74.0n sa=0 sb=0 ploda1=16.0n ploda2=0 ploda3=0 plodb1=16.0n plodb2=0 plodb3=0 nf_flag=1 smbt=1M smbb=1M dinsaflag=0 ppitch=0 spot=61.0n spob=61.0n spotl1=61.0n spobl1=61.0n spotl2=61.0n spobl2=61.0n spotr1=61.0n spobr1=61.0n spotr2=61.0n spobr2=61.0n
    Mp1 (n1 din vdd vdd) pch_svt_mac l=16.0n nfin=4 w=154.00n multi=1 nf=1 sd=74.0n sa=0 sb=0 ploda1=16.0n ploda2=0 ploda3=0 plodb1=16.0n plodb2=0 plodb3=0 nf_flag=1 smbt=1M smbb=1M dinsaflag=0 ppitch=0 spot=61.0n spob=61.0n spotl1=61.0n spobl1=61.0n spotl2=61.0n spobl2=61.0n spotr1=61.0n spobr1=61.0n spotr2=61.0n spobr2=61.0n
    Mn3c (n3 n2 vss vss) nch_svt_mac l=16.0n nfin=16 w=730.0n multi=1 nf=1 sd=74.0n sa=0 sb=0 ploda1=16.0n ploda2=0 ploda3=0 plodb1=16.0n plodb2=0 plodb3=0 nf_flag=1 smbt=1M smbb=1M dinsaflag=0 ppitch=0 spot=61.0n spob=61.0n spotl1=61.0n spobl1=61.0n spotl2=61.0n spobl2=61.0n spotr1=61.0n spobr1=61.0n spotr2=61.0n spobr2=61.0n
    Mn3b (n3 n2 vss vss) nch_svt_mac l=16.0n nfin=16 w=730.0n multi=1 nf=1 sd=74.0n sa=0 sb=0 ploda1=16.0n ploda2=0 ploda3=0 plodb1=16.0n plodb2=0 plodb3=0 nf_flag=1 smbt=1M smbb=1M dinsaflag=0 ppitch=0 spot=61.0n spob=61.0n spotl1=61.0n spobl1=61.0n spotl2=61.0n spobl2=61.0n spotr1=61.0n spobr1=61.0n spotr2=61.0n spobr2=61.0n
    Mn3a (n3 n2 vss vss) nch_svt_mac l=16.0n nfin=16 w=730.0n multi=1 nf=1 sd=74.0n sa=0 sb=0 ploda1=16.0n ploda2=0 ploda3=0 plodb1=16.0n plodb2=0 plodb3=0 nf_flag=1 smbt=1M smbb=1M dinsaflag=0 ppitch=0 spot=61.0n spob=61.0n spotl1=61.0n spobl1=61.0n spotl2=61.0n spobl2=61.0n spotr1=61.0n spobr1=61.0n spotr2=61.0n spobr2=61.0n
    Mn2b (n2 n1 vss vss) nch_svt_mac l=16.0n nfin=16 w=730.0n multi=1 nf=1 sd=74.0n sa=0 sb=0 ploda1=16.0n ploda2=0 ploda3=0 plodb1=16.0n plodb2=0 plodb3=0 nf_flag=1 smbt=1M smbb=1M dinsaflag=0 ppitch=0 spot=61.0n spob=61.0n spotl1=61.0n spobl1=61.0n spotl2=61.0n spobl2=61.0n spotr1=61.0n spobr1=61.0n spotr2=61.0n spobr2=61.0n
    Mn2a (n2 n1 vss vss) nch_svt_mac l=16.0n nfin=16 w=730.0n multi=1 nf=1 sd=74.0n sa=0 sb=0 ploda1=16.0n ploda2=0 ploda3=0 plodb1=16.0n plodb2=0 plodb3=0 nf_flag=1 smbt=1M smbb=1M dinsaflag=0 ppitch=0 spot=61.0n spob=61.0n spotl1=61.0n spobl1=61.0n spotl2=61.0n spobl2=61.0n spotr1=61.0n spobr1=61.0n spotr2=61.0n spobr2=61.0n
    Mn1 (n1 din vss vss) nch_svt_mac l=16.0n nfin=2 w=58.0n multi=1 nf=1 sd=74.0n sa=0 sb=0 ploda1=16.0n ploda2=0 ploda3=0 plodb1=16.0n plodb2=0 plodb3=0 nf_flag=1 smbt=1M smbb=1M dinsaflag=0 ppitch=0 spot=103.00n spob=103.00n spotl1=103.00n spobl1=103.00n spotl2=103.00n spobl2=103.00n spotr1=103.00n spobr1=103.00n spotr2=103.00n spobr2=103.00n
    Mpu16 (pad n3 vccio vccio) pch_ulvt_mac l=16.0n nfin=16 w=730.0n multi=1 nf=1 sd=74.0n sa=0 sb=0 ploda1=16.0n ploda2=0 ploda3=0 plodb1=16.0n plodb2=0 plodb3=0 nf_flag=1 smbt=1M smbb=1M dinsaflag=0 ppitch=0 spot=61.0n spob=61.0n spotl1=61.0n spobl1=61.0n spotl2=61.0n spobl2=61.0n spotr1=61.0n spobr1=61.0n spotr2=61.0n spobr2=61.0n
    Mpu15 (pad n3 vccio vccio) pch_ulvt_mac l=16.0n nfin=16 w=730.0n multi=1 nf=1 sd=74.0n sa=0 sb=0 ploda1=16.0n ploda2=0 ploda3=0 plodb1=16.0n plodb2=0 plodb3=0 nf_flag=1 smbt=1M smbb=1M dinsaflag=0 ppitch=0 spot=61.0n spob=61.0n spotl1=61.0n spobl1=61.0n spotl2=61.0n spobl2=61.0n spotr1=61.0n spobr1=61.0n spotr2=61.0n spobr2=61.0n
    Mpu14 (pad n3 vccio vccio) pch_ulvt_mac l=16.0n nfin=16 w=730.0n multi=1 nf=1 sd=74.0n sa=0 sb=0 ploda1=16.0n ploda2=0 ploda3=0 plodb1=16.0n plodb2=0 plodb3=0 nf_flag=1 smbt=1M smbb=1M dinsaflag=0 ppitch=0 spot=61.0n spob=61.0n spotl1=61.0n spobl1=61.0n spotl2=61.0n spobl2=61.0n spotr1=61.0n spobr1=61.0n spotr2=61.0n spobr2=61.0n
    Mpu13 (pad n3 vccio vccio) pch_ulvt_mac l=16.0n nfin=16 w=730.0n multi=1 nf=1 sd=74.0n sa=0 sb=0 ploda1=16.0n ploda2=0 ploda3=0 plodb1=16.0n plodb2=0 plodb3=0 nf_flag=1 smbt=1M smbb=1M dinsaflag=0 ppitch=0 spot=61.0n spob=61.0n spotl1=61.0n spobl1=61.0n spotl2=61.0n spobl2=61.0n spotr1=61.0n spobr1=61.0n spotr2=61.0n spobr2=61.0n
    Mpu12 (pad n3 vccio vccio) pch_ulvt_mac l=16.0n nfin=16 w=730.0n multi=1 nf=1 sd=74.0n sa=0 sb=0 ploda1=16.0n ploda2=0 ploda3=0 plodb1=16.0n plodb2=0 plodb3=0 nf_flag=1 smbt=1M smbb=1M dinsaflag=0 ppitch=0 spot=61.0n spob=61.0n spotl1=61.0n spobl1=61.0n spotl2=61.0n spobl2=61.0n spotr1=61.0n spobr1=61.0n spotr2=61.0n spobr2=61.0n
    Mpu11 (pad n3 vccio vccio) pch_ulvt_mac l=16.0n nfin=16 w=730.0n multi=1 nf=1 sd=74.0n sa=0 sb=0 ploda1=16.0n ploda2=0 ploda3=0 plodb1=16.0n plodb2=0 plodb3=0 nf_flag=1 smbt=1M smbb=1M dinsaflag=0 ppitch=0 spot=61.0n spob=61.0n spotl1=61.0n spobl1=61.0n spotl2=61.0n spobl2=61.0n spotr1=61.0n spobr1=61.0n spotr2=61.0n spobr2=61.0n
    Mpu10 (pad n3 vccio vccio) pch_ulvt_mac l=16.0n nfin=16 w=730.0n multi=1 nf=1 sd=74.0n sa=0 sb=0 ploda1=16.0n ploda2=0 ploda3=0 plodb1=16.0n plodb2=0 plodb3=0 nf_flag=1 smbt=1M smbb=1M dinsaflag=0 ppitch=0 spot=61.0n spob=61.0n spotl1=61.0n spobl1=61.0n spotl2=61.0n spobl2=61.0n spotr1=61.0n spobr1=61.0n spotr2=61.0n spobr2=61.0n
    Mpu09 (pad n3 vccio vccio) pch_ulvt_mac l=16.0n nfin=16 w=730.0n multi=1 nf=1 sd=74.0n sa=0 sb=0 ploda1=16.0n ploda2=0 ploda3=0 plodb1=16.0n plodb2=0 plodb3=0 nf_flag=1 smbt=1M smbb=1M dinsaflag=0 ppitch=0 spot=61.0n spob=61.0n spotl1=61.0n spobl1=61.0n spotl2=61.0n spobl2=61.0n spotr1=61.0n spobr1=61.0n spotr2=61.0n spobr2=61.0n
    Mpu08 (pad n3 vccio vccio) pch_ulvt_mac l=16.0n nfin=16 w=730.0n multi=1 nf=1 sd=74.0n sa=0 sb=0 ploda1=16.0n ploda2=0 ploda3=0 plodb1=16.0n plodb2=0 plodb3=0 nf_flag=1 smbt=1M smbb=1M dinsaflag=0 ppitch=0 spot=61.0n spob=61.0n spotl1=61.0n spobl1=61.0n spotl2=61.0n spobl2=61.0n spotr1=61.0n spobr1=61.0n spotr2=61.0n spobr2=61.0n
    Mpu07 (pad n3 vccio vccio) pch_ulvt_mac l=16.0n nfin=16 w=730.0n multi=1 nf=1 sd=74.0n sa=0 sb=0 ploda1=16.0n ploda2=0 ploda3=0 plodb1=16.0n plodb2=0 plodb3=0 nf_flag=1 smbt=1M smbb=1M dinsaflag=0 ppitch=0 spot=61.0n spob=61.0n spotl1=61.0n spobl1=61.0n spotl2=61.0n spobl2=61.0n spotr1=61.0n spobr1=61.0n spotr2=61.0n spobr2=61.0n
    Mpu06 (pad n3 vccio vccio) pch_ulvt_mac l=16.0n nfin=16 w=730.0n multi=1 nf=1 sd=74.0n sa=0 sb=0 ploda1=16.0n ploda2=0 ploda3=0 plodb1=16.0n plodb2=0 plodb3=0 nf_flag=1 smbt=1M smbb=1M dinsaflag=0 ppitch=0 spot=61.0n spob=61.0n spotl1=61.0n spobl1=61.0n spotl2=61.0n spobl2=61.0n spotr1=61.0n spobr1=61.0n spotr2=61.0n spobr2=61.0n
    Mpu05 (pad n3 vccio vccio) pch_ulvt_mac l=16.0n nfin=16 w=730.0n multi=1 nf=1 sd=74.0n sa=0 sb=0 ploda1=16.0n ploda2=0 ploda3=0 plodb1=16.0n plodb2=0 plodb3=0 nf_flag=1 smbt=1M smbb=1M dinsaflag=0 ppitch=0 spot=61.0n spob=61.0n spotl1=61.0n spobl1=61.0n spotl2=61.0n spobl2=61.0n spotr1=61.0n spobr1=61.0n spotr2=61.0n spobr2=61.0n
    Mpu04 (pad n3 vccio vccio) pch_ulvt_mac l=16.0n nfin=16 w=730.0n multi=1 nf=1 sd=74.0n sa=0 sb=0 ploda1=16.0n ploda2=0 ploda3=0 plodb1=16.0n plodb2=0 plodb3=0 nf_flag=1 smbt=1M smbb=1M dinsaflag=0 ppitch=0 spot=61.0n spob=61.0n spotl1=61.0n spobl1=61.0n spotl2=61.0n spobl2=61.0n spotr1=61.0n spobr1=61.0n spotr2=61.0n spobr2=61.0n
    Mpu03 (pad n3 vccio vccio) pch_ulvt_mac l=16.0n nfin=16 w=730.0n multi=1 nf=1 sd=74.0n sa=0 sb=0 ploda1=16.0n ploda2=0 ploda3=0 plodb1=16.0n plodb2=0 plodb3=0 nf_flag=1 smbt=1M smbb=1M dinsaflag=0 ppitch=0 spot=61.0n spob=61.0n spotl1=61.0n spobl1=61.0n spotl2=61.0n spobl2=61.0n spotr1=61.0n spobr1=61.0n spotr2=61.0n spobr2=61.0n
    Mpu02 (pad n3 vccio vccio) pch_ulvt_mac l=16.0n nfin=16 w=730.0n multi=1 nf=1 sd=74.0n sa=0 sb=0 ploda1=16.0n ploda2=0 ploda3=0 plodb1=16.0n plodb2=0 plodb3=0 nf_flag=1 smbt=1M smbb=1M dinsaflag=0 ppitch=0 spot=61.0n spob=61.0n spotl1=61.0n spobl1=61.0n spotl2=61.0n spobl2=61.0n spotr1=61.0n spobr1=61.0n spotr2=61.0n spobr2=61.0n
    Mpu01 (pad n3 vccio vccio) pch_ulvt_mac l=16.0n nfin=16 w=730.0n multi=1 nf=1 sd=74.0n sa=0 sb=0 ploda1=16.0n ploda2=0 ploda3=0 plodb1=16.0n plodb2=0 plodb3=0 nf_flag=1 smbt=1M smbb=1M dinsaflag=0 ppitch=0 spot=61.0n spob=61.0n spotl1=61.0n spobl1=61.0n spotl2=61.0n spobl2=61.0n spotr1=61.0n spobr1=61.0n spotr2=61.0n spobr2=61.0n
    Mpd6 (pad n3 vss vss) nch_ulvt_mac l=16.0n nfin=16 w=730.0n multi=1 nf=1 sd=74.0n sa=0 sb=0 ploda1=16.0n ploda2=0 ploda3=0 plodb1=16.0n plodb2=0 plodb3=0 nf_flag=1 smbt=1M smbb=1M dinsaflag=0 ppitch=0 spot=61.0n spob=61.0n spotl1=61.0n spobl1=61.0n spotl2=61.0n spobl2=61.0n spotr1=61.0n spobr1=61.0n spotr2=61.0n spobr2=61.0n
    Mpd5 (pad n3 vss vss) nch_ulvt_mac l=16.0n nfin=16 w=730.0n multi=1 nf=1 sd=74.0n sa=0 sb=0 ploda1=16.0n ploda2=0 ploda3=0 plodb1=16.0n plodb2=0 plodb3=0 nf_flag=1 smbt=1M smbb=1M dinsaflag=0 ppitch=0 spot=61.0n spob=61.0n spotl1=61.0n spobl1=61.0n spotl2=61.0n spobl2=61.0n spotr1=61.0n spobr1=61.0n spotr2=61.0n spobr2=61.0n
    Mpd4 (pad n3 vss vss) nch_ulvt_mac l=16.0n nfin=16 w=730.0n multi=1 nf=1 sd=74.0n sa=0 sb=0 ploda1=16.0n ploda2=0 ploda3=0 plodb1=16.0n plodb2=0 plodb3=0 nf_flag=1 smbt=1M smbb=1M dinsaflag=0 ppitch=0 spot=61.0n spob=61.0n spotl1=61.0n spobl1=61.0n spotl2=61.0n spobl2=61.0n spotr1=61.0n spobr1=61.0n spotr2=61.0n spobr2=61.0n
    Mpd3 (pad n3 vss vss) nch_ulvt_mac l=16.0n nfin=16 w=730.0n multi=1 nf=1 sd=74.0n sa=0 sb=0 ploda1=16.0n ploda2=0 ploda3=0 plodb1=16.0n plodb2=0 plodb3=0 nf_flag=1 smbt=1M smbb=1M dinsaflag=0 ppitch=0 spot=61.0n spob=61.0n spotl1=61.0n spobl1=61.0n spotl2=61.0n spobl2=61.0n spotr1=61.0n spobr1=61.0n spotr2=61.0n spobr2=61.0n
    Mpd2 (pad n3 vss vss) nch_ulvt_mac l=16.0n nfin=16 w=730.0n multi=1 nf=1 sd=74.0n sa=0 sb=0 ploda1=16.0n ploda2=0 ploda3=0 plodb1=16.0n plodb2=0 plodb3=0 nf_flag=1 smbt=1M smbb=1M dinsaflag=0 ppitch=0 spot=61.0n spob=61.0n spotl1=61.0n spobl1=61.0n spotl2=61.0n spobl2=61.0n spotr1=61.0n spobr1=61.0n spotr2=61.0n spobr2=61.0n
    Mpd1 (pad n3 vss vss) nch_ulvt_mac l=16.0n nfin=16 w=730.0n multi=1 nf=1 sd=74.0n sa=0 sb=0 ploda1=16.0n ploda2=0 ploda3=0 plodb1=16.0n plodb2=0 plodb3=0 nf_flag=1 smbt=1M smbb=1M dinsaflag=0 ppitch=0 spot=61.0n spob=61.0n spotl1=61.0n spobl1=61.0n spotl2=61.0n spobl2=61.0n spotr1=61.0n spobr1=61.0n spotr2=61.0n spobr2=61.0n
ends afe_tx_drv

// afe_sch/afe_bias/schematic
subckt afe_bias vbias vdd vss
    Mbb (vbias vbias vss vss) nch_lvt_mac l=16.0n nfin=16 w=730.0n multi=1 nf=1 sd=74.0n sa=0 sb=0 ploda1=16.0n ploda2=0 ploda3=0 plodb1=16.0n plodb2=0 plodb3=0 nf_flag=1 smbt=1M smbb=1M dinsaflag=0 ppitch=0 spot=61.0n spob=61.0n spotl1=61.0n spobl1=61.0n spotl2=61.0n spobl2=61.0n spotr1=61.0n spobr1=61.0n spotr2=61.0n spobr2=61.0n
    Mba (vbias vbias vss vss) nch_lvt_mac l=16.0n nfin=16 w=730.0n multi=1 nf=1 sd=74.0n sa=0 sb=0 ploda1=16.0n ploda2=0 ploda3=0 plodb1=16.0n plodb2=0 plodb3=0 nf_flag=1 smbt=1M smbb=1M dinsaflag=0 ppitch=0 spot=61.0n spob=61.0n spotl1=61.0n spobl1=61.0n spotl2=61.0n spobl2=61.0n spotr1=61.0n spobr1=61.0n spotr2=61.0n spobr2=61.0n
Rb (vdd vbias ) rhim l=2.35u w=360.0n multi=(1)

    Cdec16 (vbias vss) cfmom_2t_p80 lr=1u multi=1 mxd_flag=0 nr=12 n_mxa=2 spm=3 stm=1 vapmod=2
    Cdec15 (vbias vss) cfmom_2t_p80 lr=1u multi=1 mxd_flag=0 nr=12 n_mxa=2 spm=3 stm=1 vapmod=2
    Cdec14 (vbias vss) cfmom_2t_p80 lr=1u multi=1 mxd_flag=0 nr=12 n_mxa=2 spm=3 stm=1 vapmod=2
    Cdec13 (vbias vss) cfmom_2t_p80 lr=1u multi=1 mxd_flag=0 nr=12 n_mxa=2 spm=3 stm=1 vapmod=2
    Cdec12 (vbias vss) cfmom_2t_p80 lr=1u multi=1 mxd_flag=0 nr=12 n_mxa=2 spm=3 stm=1 vapmod=2
    Cdec11 (vbias vss) cfmom_2t_p80 lr=1u multi=1 mxd_flag=0 nr=12 n_mxa=2 spm=3 stm=1 vapmod=2
    Cdec10 (vbias vss) cfmom_2t_p80 lr=1u multi=1 mxd_flag=0 nr=12 n_mxa=2 spm=3 stm=1 vapmod=2
    Cdec9 (vbias vss) cfmom_2t_p80 lr=1u multi=1 mxd_flag=0 nr=12 n_mxa=2 spm=3 stm=1 vapmod=2
    Cdec8 (vbias vss) cfmom_2t_p80 lr=1u multi=1 mxd_flag=0 nr=12 n_mxa=2 spm=3 stm=1 vapmod=2
    Cdec7 (vbias vss) cfmom_2t_p80 lr=1u multi=1 mxd_flag=0 nr=12 n_mxa=2 spm=3 stm=1 vapmod=2
    Cdec6 (vbias vss) cfmom_2t_p80 lr=1u multi=1 mxd_flag=0 nr=12 n_mxa=2 spm=3 stm=1 vapmod=2
    Cdec5 (vbias vss) cfmom_2t_p80 lr=1u multi=1 mxd_flag=0 nr=12 n_mxa=2 spm=3 stm=1 vapmod=2
    Cdec4 (vbias vss) cfmom_2t_p80 lr=1u multi=1 mxd_flag=0 nr=12 n_mxa=2 spm=3 stm=1 vapmod=2
    Cdec3 (vbias vss) cfmom_2t_p80 lr=1u multi=1 mxd_flag=0 nr=12 n_mxa=2 spm=3 stm=1 vapmod=2
    Cdec2 (vbias vss) cfmom_2t_p80 lr=1u multi=1 mxd_flag=0 nr=12 n_mxa=2 spm=3 stm=1 vapmod=2
    Cdec1 (vbias vss) cfmom_2t_p80 lr=1u multi=1 mxd_flag=0 nr=12 n_mxa=2 spm=3 stm=1 vapmod=2
ends afe_bias

// afe_sch/afecmp_bank/schematic
subckt afecmp_bank az eval gp outn outp vbias vdd vin vref vss
    C2 (vref gn) capacitor c=80f
    C1 (pA gp) capacitor c=80f
    Rbgn (gn vss) resistor r=1T
    Rbgp (gp vss) resistor r=1T
    RbpA (pA vss) resistor r=1T
    MN2n (outp s1n t2 vss) nch_ulvt_mac l=16.0n nfin=6 w=250.0n multi=1 nf=1 sd=74.0n sa=0 sb=0 ploda1=16.0n ploda2=0 ploda3=0 plodb1=16.0n plodb2=0 plodb3=0 nf_flag=1 smbt=1M smbb=1M dinsaflag=0 ppitch=0 spot=61.0n spob=61.0n spotl1=61.0n spobl1=61.0n spotl2=61.0n spobl2=61.0n spotr1=61.0n spobr1=61.0n spotr2=61.0n spobr2=61.0n
    MN2p (outn s1p t2 vss) nch_ulvt_mac l=16.0n nfin=6 w=250.0n multi=1 nf=1 sd=74.0n sa=0 sb=0 ploda1=16.0n ploda2=0 ploda3=0 plodb1=16.0n plodb2=0 plodb3=0 nf_flag=1 smbt=1M smbb=1M dinsaflag=0 ppitch=0 spot=61.0n spob=61.0n spotl1=61.0n spobl1=61.0n spotl2=61.0n spobl2=61.0n spotr1=61.0n spobr1=61.0n spotr2=61.0n spobr2=61.0n
    MazGn (gn az vbias vss) nch_ulvt_mac l=16.0n nfin=8 w=346.00n multi=1 nf=1 sd=74.0n sa=0 sb=0 ploda1=16.0n ploda2=0 ploda3=0 plodb1=16.0n plodb2=0 plodb3=0 nf_flag=1 smbt=1M smbb=1M dinsaflag=0 ppitch=0 spot=61.0n spob=61.0n spotl1=61.0n spobl1=61.0n spotl2=61.0n spobl2=61.0n spotr1=61.0n spobr1=61.0n spotr2=61.0n spobr2=61.0n
    MazGp (gp az vbias vss) nch_ulvt_mac l=16.0n nfin=8 w=346.00n multi=1 nf=1 sd=74.0n sa=0 sb=0 ploda1=16.0n ploda2=0 ploda3=0 plodb1=16.0n plodb2=0 plodb3=0 nf_flag=1 smbt=1M smbb=1M dinsaflag=0 ppitch=0 spot=61.0n spob=61.0n spotl1=61.0n spobl1=61.0n spotl2=61.0n spobl2=61.0n spotr1=61.0n spobr1=61.0n spotr2=61.0n spobr2=61.0n
    MazA (pA az vref vss) nch_ulvt_mac l=16.0n nfin=8 w=346.00n multi=1 nf=1 sd=74.0n sa=0 sb=0 ploda1=16.0n ploda2=0 ploda3=0 plodb1=16.0n plodb2=0 plodb3=0 nf_flag=1 smbt=1M smbb=1M dinsaflag=0 ppitch=0 spot=61.0n spob=61.0n spotl1=61.0n spobl1=61.0n spotl2=61.0n spobl2=61.0n spotr1=61.0n spobr1=61.0n spotr2=61.0n spobr2=61.0n
    Msw (pA eval vin vss) nch_ulvt_mac l=16.0n nfin=8 w=346.00n multi=1 nf=1 sd=74.0n sa=0 sb=0 ploda1=16.0n ploda2=0 ploda3=0 plodb1=16.0n plodb2=0 plodb3=0 nf_flag=1 smbt=1M smbb=1M dinsaflag=0 ppitch=0 spot=61.0n spob=61.0n spotl1=61.0n spobl1=61.0n spotl2=61.0n spobl2=61.0n spotr1=61.0n spobr1=61.0n spotr2=61.0n spobr2=61.0n
    MNn (s1p gn tA vss) nch_lvt_mac l=16.0n nfin=8 w=346.00n multi=1 nf=1 sd=74.0n sa=0 sb=0 ploda1=16.0n ploda2=0 ploda3=0 plodb1=16.0n plodb2=0 plodb3=0 nf_flag=1 smbt=1M smbb=1M dinsaflag=0 ppitch=0 spot=61.0n spob=61.0n spotl1=61.0n spobl1=61.0n spotl2=61.0n spobl2=61.0n spotr1=61.0n spobr1=61.0n spotr2=61.0n spobr2=61.0n
    MNp (s1n gp tA vss) nch_lvt_mac l=16.0n nfin=8 w=346.00n multi=1 nf=1 sd=74.0n sa=0 sb=0 ploda1=16.0n ploda2=0 ploda3=0 plodb1=16.0n plodb2=0 plodb3=0 nf_flag=1 smbt=1M smbb=1M dinsaflag=0 ppitch=0 spot=61.0n spob=61.0n spotl1=61.0n spobl1=61.0n spotl2=61.0n spobl2=61.0n spotr1=61.0n spobr1=61.0n spotr2=61.0n spobr2=61.0n
    ML2n (outn outn vdd vdd) pch_svt_mac l=16.0n nfin=2 w=58.0n multi=1 nf=1 sd=74.0n sa=0 sb=0 ploda1=16.0n ploda2=0 ploda3=0 plodb1=16.0n plodb2=0 plodb3=0 nf_flag=1 smbt=1M smbb=1M dinsaflag=0 ppitch=0 spot=103.00n spob=103.00n spotl1=103.00n spobl1=103.00n spotl2=103.00n spobl2=103.00n spotr1=103.00n spobr1=103.00n spotr2=103.00n spobr2=103.00n
    ML2p (outp outp vdd vdd) pch_svt_mac l=16.0n nfin=2 w=58.0n multi=1 nf=1 sd=74.0n sa=0 sb=0 ploda1=16.0n ploda2=0 ploda3=0 plodb1=16.0n plodb2=0 plodb3=0 nf_flag=1 smbt=1M smbb=1M dinsaflag=0 ppitch=0 spot=103.00n spob=103.00n spotl1=103.00n spobl1=103.00n spotl2=103.00n spobl2=103.00n spotr1=103.00n spobr1=103.00n spotr2=103.00n spobr2=103.00n
    MLn (s1n s1n vdd vdd) pch_svt_mac l=16.0n nfin=2 w=58.0n multi=1 nf=1 sd=74.0n sa=0 sb=0 ploda1=16.0n ploda2=0 ploda3=0 plodb1=16.0n plodb2=0 plodb3=0 nf_flag=1 smbt=1M smbb=1M dinsaflag=0 ppitch=0 spot=103.00n spob=103.00n spotl1=103.00n spobl1=103.00n spotl2=103.00n spobl2=103.00n spotr1=103.00n spobr1=103.00n spotr2=103.00n spobr2=103.00n
    MLp (s1p s1p vdd vdd) pch_svt_mac l=16.0n nfin=2 w=58.0n multi=1 nf=1 sd=74.0n sa=0 sb=0 ploda1=16.0n ploda2=0 ploda3=0 plodb1=16.0n plodb2=0 plodb3=0 nf_flag=1 smbt=1M smbb=1M dinsaflag=0 ppitch=0 spot=103.00n spob=103.00n spotl1=103.00n spobl1=103.00n spotl2=103.00n spobl2=103.00n spotr1=103.00n spobr1=103.00n spotr2=103.00n spobr2=103.00n
    Msh (outp az outn vss) nch_svt_mac l=16.0n nfin=2 w=58.0n multi=1 nf=1 sd=74.0n sa=0 sb=0 ploda1=16.0n ploda2=0 ploda3=0 plodb1=16.0n plodb2=0 plodb3=0 nf_flag=1 smbt=1M smbb=1M dinsaflag=0 ppitch=0 spot=103.00n spob=103.00n spotl1=103.00n spobl1=103.00n spotl2=103.00n spobl2=103.00n spotr1=103.00n spobr1=103.00n spotr2=103.00n spobr2=103.00n
    Mtail2 (t2 eval vss vss) nch_svt_mac l=16.0n nfin=6 w=250.0n multi=1 nf=1 sd=74.0n sa=0 sb=0 ploda1=16.0n ploda2=0 ploda3=0 plodb1=16.0n plodb2=0 plodb3=0 nf_flag=1 smbt=1M smbb=1M dinsaflag=0 ppitch=0 spot=61.0n spob=61.0n spotl1=61.0n spobl1=61.0n spotl2=61.0n spobl2=61.0n spotr1=61.0n spobr1=61.0n spotr2=61.0n spobr2=61.0n
    Mtail (tA eval vss vss) nch_svt_mac l=16.0n nfin=8 w=346.00n multi=1 nf=1 sd=74.0n sa=0 sb=0 ploda1=16.0n ploda2=0 ploda3=0 plodb1=16.0n plodb2=0 plodb3=0 nf_flag=1 smbt=1M smbb=1M dinsaflag=0 ppitch=0 spot=61.0n spob=61.0n spotl1=61.0n spobl1=61.0n spotl2=61.0n spobl2=61.0n spotr1=61.0n spobr1=61.0n spotr2=61.0n spobr2=61.0n
ends afecmp_bank

// afe_sch/afe_tb_tran/schematic
G2 (vdd aggr) afe_prbs23_gen
G1 (vdd din) afe_prbs23_gen
CK (ck8 pclk pi_in vdd) afe_clk_gen
PP (a_az a_eval b_az b_eval pclk vdd) afe_pingpong
SMP (act_n act_p ck8 d_even d_odd vdd) afe_samp
CHK (bit_cnt ck8 d_even d_odd err_cnt lock vdd) afe_ber_chk
DRV (din tx_pad vccio vdd vss) afe_tx_drv
BIAS (vbias vdd vss) afe_bias
BB (b_az_g b_eval gp_b cmp_b_n cmp_b_p vbias vdd rx_in vref vss) afecmp_bank
BA (a_az_g a_eval gp_a cmp_a_n cmp_a_p vbias vdd rx_in vref vss) afecmp_bank
Rser (tx_pad ntx) resistor r=1.5
TL (ntx vss rx_in vss) tline z0=50 nl=0.25
Crx (rx_in vss) capacitor c=50f
Cxt (aggr rx_in) capacitor c=8f
Vcb7 (codeb7 vss) vsource type=dc
Vcb6 (codeb6 vss) vsource type=dc
Vcb5 (codeb5 vss) vsource type=dc
Vcb4 (codeb4 vss) vsource type=dc
Vcb3 (codeb3 vss) vsource type=dc
Vcb2 (codeb2 vss) vsource type=dc
Vcb1 (codeb1 vss) vsource type=dc
Vcb0 (codeb0 vss) vsource type=dc
Vpi (pi_in vss) vsource type=dc
EazB (b_az_g vss b_az vss) vcvs gain=1.0
EazA (a_az_g vss a_az vss) vcvs gain=1.0
Idr (vss gp_a) isource type=dc
MtgBn (cmp_b_n b_eval act_n vss) nch_svt_mac l=16.0n nfin=4 w=154.00n multi=1 nf=1 sd=74.0n sa=0 sb=0 ploda1=16.0n ploda2=0 ploda3=0 plodb1=16.0n plodb2=0 plodb3=0 nf_flag=1 smbt=1M smbb=1M dinsaflag=0 ppitch=0 spot=61.0n spob=61.0n spotl1=61.0n spobl1=61.0n spotl2=61.0n spobl2=61.0n spotr1=61.0n spobr1=61.0n spotr2=61.0n spobr2=61.0n
MtgBp (cmp_b_p b_eval act_p vss) nch_svt_mac l=16.0n nfin=4 w=154.00n multi=1 nf=1 sd=74.0n sa=0 sb=0 ploda1=16.0n ploda2=0 ploda3=0 plodb1=16.0n plodb2=0 plodb3=0 nf_flag=1 smbt=1M smbb=1M dinsaflag=0 ppitch=0 spot=61.0n spob=61.0n spotl1=61.0n spobl1=61.0n spotl2=61.0n spobl2=61.0n spotr1=61.0n spobr1=61.0n spotr2=61.0n spobr2=61.0n
MtgAn (cmp_a_n a_eval act_n vss) nch_svt_mac l=16.0n nfin=4 w=154.00n multi=1 nf=1 sd=74.0n sa=0 sb=0 ploda1=16.0n ploda2=0 ploda3=0 plodb1=16.0n plodb2=0 plodb3=0 nf_flag=1 smbt=1M smbb=1M dinsaflag=0 ppitch=0 spot=61.0n spob=61.0n spotl1=61.0n spobl1=61.0n spotl2=61.0n spobl2=61.0n spotr1=61.0n spobr1=61.0n spotr2=61.0n spobr2=61.0n
MtgAp (cmp_a_p a_eval act_p vss) nch_svt_mac l=16.0n nfin=4 w=154.00n multi=1 nf=1 sd=74.0n sa=0 sb=0 ploda1=16.0n ploda2=0 ploda3=0 plodb1=16.0n plodb2=0 plodb3=0 nf_flag=1 smbt=1M smbb=1M dinsaflag=0 ppitch=0 spot=61.0n spob=61.0n spotl1=61.0n spobl1=61.0n spotl2=61.0n spobl2=61.0n spotr1=61.0n spobr1=61.0n spotr2=61.0n spobr2=61.0n
MpgBn (cmp_b_n a_eval act_n vdd) pch_svt_mac l=16.0n nfin=4 w=154.00n multi=1 nf=1 sd=74.0n sa=0 sb=0 ploda1=16.0n ploda2=0 ploda3=0 plodb1=16.0n plodb2=0 plodb3=0 nf_flag=1 smbt=1M smbb=1M dinsaflag=0 ppitch=0 spot=61.0n spob=61.0n spotl1=61.0n spobl1=61.0n spotl2=61.0n spobl2=61.0n spotr1=61.0n spobr1=61.0n spotr2=61.0n spobr2=61.0n
MpgBp (cmp_b_p a_eval act_p vdd) pch_svt_mac l=16.0n nfin=4 w=154.00n multi=1 nf=1 sd=74.0n sa=0 sb=0 ploda1=16.0n ploda2=0 ploda3=0 plodb1=16.0n plodb2=0 plodb3=0 nf_flag=1 smbt=1M smbb=1M dinsaflag=0 ppitch=0 spot=61.0n spob=61.0n spotl1=61.0n spobl1=61.0n spotl2=61.0n spobl2=61.0n spotr1=61.0n spobr1=61.0n spotr2=61.0n spobr2=61.0n
MpgAn (cmp_a_n b_eval act_n vdd) pch_svt_mac l=16.0n nfin=4 w=154.00n multi=1 nf=1 sd=74.0n sa=0 sb=0 ploda1=16.0n ploda2=0 ploda3=0 plodb1=16.0n plodb2=0 plodb3=0 nf_flag=1 smbt=1M smbb=1M dinsaflag=0 ppitch=0 spot=61.0n spob=61.0n spotl1=61.0n spobl1=61.0n spotl2=61.0n spobl2=61.0n spotr1=61.0n spobr1=61.0n spotr2=61.0n spobr2=61.0n
MpgAp (cmp_a_p b_eval act_p vdd) pch_svt_mac l=16.0n nfin=4 w=154.00n multi=1 nf=1 sd=74.0n sa=0 sb=0 ploda1=16.0n ploda2=0 ploda3=0 plodb1=16.0n plodb2=0 plodb3=0 nf_flag=1 smbt=1M smbb=1M dinsaflag=0 ppitch=0 spot=61.0n spob=61.0n spotl1=61.0n spobl1=61.0n spotl2=61.0n spobl2=61.0n spotr1=61.0n spobr1=61.0n spotr2=61.0n spobr2=61.0n
