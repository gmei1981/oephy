// UCIe-AP RX AFE golden TB (tb_afe_va) -- si export assembled by scripts/gen_tb_golden.py
simulator lang=spectre

ahdl_include "afe_prbs23_gen.va"
ahdl_include "afe_tx_driver.va"
ahdl_include "afe_channel.va"
ahdl_include "afe_clk_gen.va"
ahdl_include "afe_vref_dac.va"
ahdl_include "afe_azcmp.va"
ahdl_include "afe_pingpong.va"
ahdl_include "afe_rx_slice.va"
ahdl_include "afe_ber_chk.va"
ahdl_include "afe_tb.va"
// Library name: afe_sch
// Cell name: tb_afe_va
// View name: schematic
Xtb (tx_pad rx_in vref ck8 pclk d_even d_odd lock err_cnt bit_cnt) afe_tb vref_code=__VC__ pi_code=__PC__ vos_a=__VOSA__ vos_b=__VOSB__ az_resid=__AZR__ n_shift=__NS__

// ---- directives (verbatim from tb_afe_va.scs) ----
tran tran stop=__STOP__ maxstep=4p errpreset=liberal method=trap skipdc=yes annotate=status

saveOptions options save=selected
save tx_pad rx_in vref ck8 pclk
save d_even d_odd lock err_cnt bit_cnt
