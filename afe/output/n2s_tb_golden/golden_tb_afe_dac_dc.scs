// UCIe-AP RX AFE golden TB (tb_afe_dac_dc) -- si export assembled by scripts/gen_tb_golden.py
simulator lang=spectre

include "/home/lib/tsmc_12nm_installed/pdk/models/toplevel.scs" section=top_tt
// afe_sch/afe_dac_r2r/schematic
subckt afe_dac_r2r b0 b1 b2 b3 b4 b5 b6 b7 vccio vdd vref vss
    Mdn7pb (m7 b0 vss vdd) pch_svt_mac l=16n nfin=16
    Mdn7pa (m7 b0 vss vdd) pch_svt_mac l=16n nfin=16
    Mup7pb (m7 b0n vccio vdd) pch_svt_mac l=16n nfin=16
    Mup7pa (m7 b0n vccio vdd) pch_svt_mac l=16n nfin=16
    Mdn6pb (m6 b1 vss vdd) pch_svt_mac l=16n nfin=16
    Mdn6pa (m6 b1 vss vdd) pch_svt_mac l=16n nfin=16
    Mup6pb (m6 b1n vccio vdd) pch_svt_mac l=16n nfin=16
    Mup6pa (m6 b1n vccio vdd) pch_svt_mac l=16n nfin=16
    Mdn5pb (m5 b2 vss vdd) pch_svt_mac l=16n nfin=16
    Mdn5pa (m5 b2 vss vdd) pch_svt_mac l=16n nfin=16
    Mup5pb (m5 b2n vccio vdd) pch_svt_mac l=16n nfin=16
    Mup5pa (m5 b2n vccio vdd) pch_svt_mac l=16n nfin=16
    Mdn4pb (m4 b3 vss vdd) pch_svt_mac l=16n nfin=16
    Mdn4pa (m4 b3 vss vdd) pch_svt_mac l=16n nfin=16
    Mup4pb (m4 b3n vccio vdd) pch_svt_mac l=16n nfin=16
    Mup4pa (m4 b3n vccio vdd) pch_svt_mac l=16n nfin=16
    Mdn3pb (m3 b4 vss vdd) pch_svt_mac l=16n nfin=16
    Mdn3pa (m3 b4 vss vdd) pch_svt_mac l=16n nfin=16
    Mup3pb (m3 b4n vccio vdd) pch_svt_mac l=16n nfin=16
    Mup3pa (m3 b4n vccio vdd) pch_svt_mac l=16n nfin=16
    Mdn2pb (m2 b5 vss vdd) pch_svt_mac l=16n nfin=16
    Mdn2pa (m2 b5 vss vdd) pch_svt_mac l=16n nfin=16
    Mup2pb (m2 b5n vccio vdd) pch_svt_mac l=16n nfin=16
    Mup2pa (m2 b5n vccio vdd) pch_svt_mac l=16n nfin=16
    Mdn1pb (m1 b6 vss vdd) pch_svt_mac l=16n nfin=16
    Mdn1pa (m1 b6 vss vdd) pch_svt_mac l=16n nfin=16
    Mup1pb (m1 b6n vccio vdd) pch_svt_mac l=16n nfin=16
    Mup1pa (m1 b6n vccio vdd) pch_svt_mac l=16n nfin=16
    Mdn0pb (m0 b7 vss vdd) pch_svt_mac l=16n nfin=16
    Mdn0pa (m0 b7 vss vdd) pch_svt_mac l=16n nfin=16
    Mup0pb (m0 b7n vccio vdd) pch_svt_mac l=16n nfin=16
    Mup0pa (m0 b7n vccio vdd) pch_svt_mac l=16n nfin=16
    Minv7 (b7n b7 vdd vdd) pch_svt_mac l=16n nfin=4
    Minv6 (b6n b6 vdd vdd) pch_svt_mac l=16n nfin=4
    Minv5 (b5n b5 vdd vdd) pch_svt_mac l=16n nfin=4
    Minv4 (b4n b4 vdd vdd) pch_svt_mac l=16n nfin=4
    Minv3 (b3n b3 vdd vdd) pch_svt_mac l=16n nfin=4
    Minv2 (b2n b2 vdd vdd) pch_svt_mac l=16n nfin=4
    Minv1 (b1n b1 vdd vdd) pch_svt_mac l=16n nfin=4
    Minv0 (b0n b0 vdd vdd) pch_svt_mac l=16n nfin=4
    Mdn7nb (m7 b0n vss vss) nch_svt_mac l=16n nfin=16
    Mdn7na (m7 b0n vss vss) nch_svt_mac l=16n nfin=16
    Mup7nb (m7 b0 vccio vss) nch_svt_mac l=16n nfin=16
    Mup7na (m7 b0 vccio vss) nch_svt_mac l=16n nfin=16
    Mdn6nb (m6 b1n vss vss) nch_svt_mac l=16n nfin=16
    Mdn6na (m6 b1n vss vss) nch_svt_mac l=16n nfin=16
    Mup6nb (m6 b1 vccio vss) nch_svt_mac l=16n nfin=16
    Mup6na (m6 b1 vccio vss) nch_svt_mac l=16n nfin=16
    Mdn5nb (m5 b2n vss vss) nch_svt_mac l=16n nfin=16
    Mdn5na (m5 b2n vss vss) nch_svt_mac l=16n nfin=16
    Mup5nb (m5 b2 vccio vss) nch_svt_mac l=16n nfin=16
    Mup5na (m5 b2 vccio vss) nch_svt_mac l=16n nfin=16
    Mdn4nb (m4 b3n vss vss) nch_svt_mac l=16n nfin=16
    Mdn4na (m4 b3n vss vss) nch_svt_mac l=16n nfin=16
    Mup4nb (m4 b3 vccio vss) nch_svt_mac l=16n nfin=16
    Mup4na (m4 b3 vccio vss) nch_svt_mac l=16n nfin=16
    Mdn3nb (m3 b4n vss vss) nch_svt_mac l=16n nfin=16
    Mdn3na (m3 b4n vss vss) nch_svt_mac l=16n nfin=16
    Mup3nb (m3 b4 vccio vss) nch_svt_mac l=16n nfin=16
    Mup3na (m3 b4 vccio vss) nch_svt_mac l=16n nfin=16
    Mdn2nb (m2 b5n vss vss) nch_svt_mac l=16n nfin=16
    Mdn2na (m2 b5n vss vss) nch_svt_mac l=16n nfin=16
    Mup2nb (m2 b5 vccio vss) nch_svt_mac l=16n nfin=16
    Mup2na (m2 b5 vccio vss) nch_svt_mac l=16n nfin=16
    Mdn1nb (m1 b6n vss vss) nch_svt_mac l=16n nfin=16
    Mdn1na (m1 b6n vss vss) nch_svt_mac l=16n nfin=16
    Mup1nb (m1 b6 vccio vss) nch_svt_mac l=16n nfin=16
    Mup1na (m1 b6 vccio vss) nch_svt_mac l=16n nfin=16
    Mdn0nb (m0 b7n vss vss) nch_svt_mac l=16n nfin=16
    Mdn0na (m0 b7n vss vss) nch_svt_mac l=16n nfin=16
    Mup0nb (m0 b7 vccio vss) nch_svt_mac l=16n nfin=16
    Mup0na (m0 b7 vccio vss) nch_svt_mac l=16n nfin=16
    Mdnv7 (b7n b7 vss vss) nch_svt_mac l=16n nfin=2
    Mdnv6 (b6n b6 vss vss) nch_svt_mac l=16n nfin=2
    Mdnv5 (b5n b5 vss vss) nch_svt_mac l=16n nfin=2
    Mdnv4 (b4n b4 vss vss) nch_svt_mac l=16n nfin=2
    Mdnv3 (b3n b3 vss vss) nch_svt_mac l=16n nfin=2
    Mdnv2 (b2n b2 vss vss) nch_svt_mac l=16n nfin=2
    Mdnv1 (b1n b1 vss vss) nch_svt_mac l=16n nfin=2
    Mdnv0 (b0n b0 vss vss) nch_svt_mac l=16n nfin=2
Rterm (n7 vss ) rhim l=7.01u w=360.0n multi=(1)
Rarm7 (m7 n7 ) rhim l=7.01u w=360.0n multi=(1)
Rarm6 (m6 n6 ) rhim l=7.01u w=360.0n multi=(1)
Rarm5 (m5 n5 ) rhim l=7.01u w=360.0n multi=(1)
Rarm4 (m4 n4 ) rhim l=7.01u w=360.0n multi=(1)
Rarm3 (m3 n3 ) rhim l=7.01u w=360.0n multi=(1)
Rarm2 (m2 n2 ) rhim l=7.01u w=360.0n multi=(1)
Rarm1 (m1 n1 ) rhim l=7.01u w=360.0n multi=(1)
Rarm0 (m0 vref ) rhim l=6.95u w=360.0n multi=(1)
Rs6 (n7 n6 ) rhim l=3.51u w=360.0n multi=(1)
Rs5 (n6 n5 ) rhim l=3.51u w=360.0n multi=(1)
Rs4 (n5 n4 ) rhim l=3.51u w=360.0n multi=(1)
Rs3 (n4 n3 ) rhim l=3.51u w=360.0n multi=(1)
Rs2 (n3 n2 ) rhim l=3.51u w=360.0n multi=(1)
Rs1 (n2 n1 ) rhim l=3.51u w=360.0n multi=(1)
Rs0 (n1 vref ) rhim l=3.51u w=360.0n multi=(1)
ends afe_dac_r2r
Vvccio (vccio 0) vsource dc=0.45
Vvdd (vdd 0) vsource dc=0.8
Vb0 (b0 0) vsource dc=__B0__
Vb1 (b1 0) vsource dc=__B1__
Vb2 (b2 0) vsource dc=__B2__
Vb3 (b3 0) vsource dc=__B3__
Vb4 (b4 0) vsource dc=__B4__
Vb5 (b5 0) vsource dc=__B5__
Vb6 (b6 0) vsource dc=__B6__
// afe_sch/tb_afe_dac_dc/schematic
Vb7 (b7 0) vsource dc=__B7__
Xdac (b0 b1 b2 b3 b4 b5 b6 b7 vccio vdd vref 0) afe_dac_r2r

// ---- directives (verbatim from tb_afe_dac_dc.scs) ----
dc1 dc

saveOptions options save=selected
save vref
