// afe_sch/tb_noise_smoke/schematic
Vvdd (vdd 0) vsource type=sine
R1 (vdd out ) rhim l=10u w=360.0n multi=(1)

C1 (out vss) capacitor c=50f
M1 (out out vss vss) nch_lvt_mac l=16.0n nfin=8 w=346.00n multi=1 nf=1 sd=74.0n sa=0 sb=0 ploda1=16.0n ploda2=0 ploda3=0 plodb1=16.0n plodb2=0 plodb3=0 nf_flag=1 smbt=1M smbb=1M dinsaflag=0 ppitch=0 spot=61.0n spob=61.0n spotl1=61.0n spobl1=61.0n spotl2=61.0n spobl2=61.0n spotr1=61.0n spobr1=61.0n spotr2=61.0n spobr2=61.0n
