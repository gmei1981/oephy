// afe_sch/afe_strongarm/schematic
subckt afe_strongarm ck ckn inn inp qn qp vdd vss
    Mtsr (ts ckn vss vss) nch_svt_mac l=16.0n nfin=2 w=58.0n multi=1 nf=1 sd=74.0n sa=0 sb=0 ploda1=16.0n ploda2=0 ploda3=0 plodb1=16.0n plodb2=0 plodb3=0 nf_flag=1 smbt=1M smbb=1M dinsaflag=0 ppitch=0 spot=103.00n spob=103.00n spotl1=103.00n spobl1=103.00n spotl2=103.00n spobl2=103.00n spotr1=103.00n spobr1=103.00n spotr2=103.00n spobr2=103.00n
    Mtail (ts ck vss vss) nch_svt_mac l=16.0n nfin=6 w=250.0n multi=1 nf=1 sd=74.0n sa=0 sb=0 ploda1=16.0n ploda2=0 ploda3=0 plodb1=16.0n plodb2=0 plodb3=0 nf_flag=1 smbt=1M smbb=1M dinsaflag=0 ppitch=0 spot=61.0n spob=61.0n spotl1=61.0n spobl1=61.0n spotl2=61.0n spobl2=61.0n spotr1=61.0n spobr1=61.0n spotr2=61.0n spobr2=61.0n
    MNin (qp inn ts vss) nch_ulvt_mac l=16.0n nfin=4 w=154.00n multi=1 nf=1 sd=74.0n sa=0 sb=0 ploda1=16.0n ploda2=0 ploda3=0 plodb1=16.0n plodb2=0 plodb3=0 nf_flag=1 smbt=1M smbb=1M dinsaflag=0 ppitch=0 spot=61.0n spob=61.0n spotl1=61.0n spobl1=61.0n spotl2=61.0n spobl2=61.0n spotr1=61.0n spobr1=61.0n spotr2=61.0n spobr2=61.0n
    MNip (qn inp ts vss) nch_ulvt_mac l=16.0n nfin=4 w=154.00n multi=1 nf=1 sd=74.0n sa=0 sb=0 ploda1=16.0n ploda2=0 ploda3=0 plodb1=16.0n plodb2=0 plodb3=0 nf_flag=1 smbt=1M smbb=1M dinsaflag=0 ppitch=0 spot=61.0n spob=61.0n spotl1=61.0n spobl1=61.0n spotl2=61.0n spobl2=61.0n spotr1=61.0n spobr1=61.0n spotr2=61.0n spobr2=61.0n
    MNxn (qn qp ts vss) nch_lvt_mac l=16.0n nfin=4 w=154.00n multi=1 nf=1 sd=74.0n sa=0 sb=0 ploda1=16.0n ploda2=0 ploda3=0 plodb1=16.0n plodb2=0 plodb3=0 nf_flag=1 smbt=1M smbb=1M dinsaflag=0 ppitch=0 spot=61.0n spob=61.0n spotl1=61.0n spobl1=61.0n spotl2=61.0n spobl2=61.0n spotr1=61.0n spobr1=61.0n spotr2=61.0n spobr2=61.0n
    MNxp (qp qn ts vss) nch_lvt_mac l=16.0n nfin=4 w=154.00n multi=1 nf=1 sd=74.0n sa=0 sb=0 ploda1=16.0n ploda2=0 ploda3=0 plodb1=16.0n plodb2=0 plodb3=0 nf_flag=1 smbt=1M smbb=1M dinsaflag=0 ppitch=0 spot=61.0n spob=61.0n spotl1=61.0n spobl1=61.0n spotl2=61.0n spobl2=61.0n spotr1=61.0n spobr1=61.0n spotr2=61.0n spobr2=61.0n
    MPprn (qn ck vdd vdd) pch_svt_mac l=16.0n nfin=2 w=58.0n multi=1 nf=1 sd=74.0n sa=0 sb=0 ploda1=16.0n ploda2=0 ploda3=0 plodb1=16.0n plodb2=0 plodb3=0 nf_flag=1 smbt=1M smbb=1M dinsaflag=0 ppitch=0 spot=103.00n spob=103.00n spotl1=103.00n spobl1=103.00n spotl2=103.00n spobl2=103.00n spotr1=103.00n spobr1=103.00n spotr2=103.00n spobr2=103.00n
    MPprp (qp ck vdd vdd) pch_svt_mac l=16.0n nfin=2 w=58.0n multi=1 nf=1 sd=74.0n sa=0 sb=0 ploda1=16.0n ploda2=0 ploda3=0 plodb1=16.0n plodb2=0 plodb3=0 nf_flag=1 smbt=1M smbb=1M dinsaflag=0 ppitch=0 spot=103.00n spob=103.00n spotl1=103.00n spobl1=103.00n spotl2=103.00n spobl2=103.00n spotr1=103.00n spobr1=103.00n spotr2=103.00n spobr2=103.00n
    MPxn (qn qp vdd vdd) pch_svt_mac l=16.0n nfin=4 w=154.00n multi=1 nf=1 sd=74.0n sa=0 sb=0 ploda1=16.0n ploda2=0 ploda3=0 plodb1=16.0n plodb2=0 plodb3=0 nf_flag=1 smbt=1M smbb=1M dinsaflag=0 ppitch=0 spot=61.0n spob=61.0n spotl1=61.0n spobl1=61.0n spotl2=61.0n spobl2=61.0n spotr1=61.0n spobr1=61.0n spotr2=61.0n spobr2=61.0n
    MPxp (qp qn vdd vdd) pch_svt_mac l=16.0n nfin=4 w=154.00n multi=1 nf=1 sd=74.0n sa=0 sb=0 ploda1=16.0n ploda2=0 ploda3=0 plodb1=16.0n plodb2=0 plodb3=0 nf_flag=1 smbt=1M smbb=1M dinsaflag=0 ppitch=0 spot=61.0n spob=61.0n spotl1=61.0n spobl1=61.0n spotl2=61.0n spobl2=61.0n spotr1=61.0n spobr1=61.0n spotr2=61.0n spobr2=61.0n
ends afe_strongarm

// afe_sch/tb_sa_test/schematic
vvss (vss 0) vsource type=sine
vvdd (vdd 0) vsource type=sine
vckn (ckn 0) vsource type=sine
vck (ck 0) vsource type=sine
vinn (in 0) vsource type=sine
vinp (ip 0) vsource type=sine
Xsa (ck ckn in ip qn qp vdd vss) afe_strongarm
